* audio_412_bridge_linear_no_nonlinearity_control: physical 4->8->12 nonlinear LC bridge
* scale=audio-scale; role=discovery; nonlinear_variant=linear_no_nonlinearity_control
* Generated by spice_412_export.py.
* Discovery rule: no direct generated/target drive and no target-frequency injection.
* The direct 4+8 file is a separated ceiling/reference denominator only.
.option method=gear reltol=1e-5 abstol=1e-12 vntol=1e-8 maxord=2
.param pi=3.141592653589793
.param tstop=0.110454545455
.param tstep=3.55113636364e-05
.param drive_until=0.0817363636364
.param drive_ramp=0.00409090909091

* Drive envelope: source ramps in, holds, then ramps out before the transient ends.
Venv env 0 PWL(0 0 0.00409090909091 1 0.0776454545455 1 0.0817363636364 0 0.110454545455 0)

* Three lossy LC resonators. R is the inductor-branch loss selected from Q=omega*L/R.
.param c1=1e-05
.param l1=0.0130838305323
.param r1=0.911523764981
C1 n1 0 {c1}
R1 n1 n1l {r1}
L1 n1l 0 {l1} IC=0
.param c2=4.7e-06
.param l2=0.00689829930385
.param r2=0.901071814648
C2 n2 0 {c2}
R2 n2 n2l {r2}
L2 n2l 0 {l2} IC=0
.param c3=3.3e-06
.param l3=0.00447378724669
.param r3=0.479540267477
C3 n3 0 {c3}
R3 n3 n3l {r3}
L3 n3l 0 {l3} IC=0

* Weak linear coupling, exported as mutual inductive coupling between the LC tanks.
K12 L1 L2 0.0042704516129
K23 L2 L3 0.00420169354839

* Nonlinear variant: linear_no_nonlinearity_control
* Linear LC and weak coupling only; should not reproduce the nonlinear bridge.
* Linear control: no nonlinear capacitance, diode, saturable, limiter, or behavioral mixing elements.

* External drives.
* source-only discovery drive: mode 1, f=440 Hz
.param idrive1=0.0193522107461
.param fdrive1=440
Bdrive1 n1 0 I={-idrive1*V(env)*sin(2*pi*fdrive1*time)}

.ic V(n1)=0 V(n2)=0 V(n3)=0
.tran {tstep} {tstop} 0 {tstep} uic
.control
set noaskquit
set wr_singlescale
set wr_vecnames
run
wrdata audio_412_bridge_linear_no_nonlinearity_control_tran.csv time v(n1) v(n2) v(n3) i(L1) i(L2) i(L3)
write audio_412_bridge_linear_no_nonlinearity_control.raw v(n1) v(n2) v(n3) i(L1) i(L2) i(L3)
quit
.endc
.end

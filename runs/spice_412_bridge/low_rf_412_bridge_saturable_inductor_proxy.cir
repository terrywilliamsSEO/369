* low_rf_412_bridge_saturable_inductor_proxy: physical 4->8->12 nonlinear LC bridge
* scale=low-RF-scale; role=discovery; nonlinear_variant=saturable_inductor_proxy
* Generated by spice_412_export.py.
* Discovery rule: no direct generated/target drive and no target-frequency injection.
* The direct 4+8 file is a separated ceiling/reference denominator only.
.option method=gear reltol=1e-5 abstol=1e-12 vntol=1e-8 maxord=2
.param pi=3.141592653589793
.param tstop=4.86e-05
.param tstep=1.5625e-08
.param drive_until=3.5964e-05
.param drive_ramp=1.8e-06

* Drive envelope: source ramps in, holds, then ramps out before the transient ends.
Venv env 0 PWL(0 0 1.8e-06 1 3.4164e-05 1 3.5964e-05 0 4.86e-05 0)

* Three lossy LC resonators. R is the inductor-branch loss selected from Q=omega*L/R.
.param c1=1e-09
.param l1=2.53302959106e-05
.param r1=4.01070456592
C1 n1 0 {c1}
R1 n1 n1l {r1}
L1 n1l 0 {l1} IC=0
.param c2=4.7e-10
.param l2=1.33551074523e-05
.param r2=3.96471598445
C2 n2 0 {c2}
R2 n2 n2l {r2}
L2 n2l 0 {l2} IC=0
.param c3=3.3e-10
.param l3=8.66125210959e-06
.param r3=2.1099771769
C3 n3 0 {c3}
R3 n3 n3l {r3}
L3 n3l 0 {l3} IC=0

* Weak linear coupling, exported as mutual inductive coupling between the LC tanks.
K12 L1 L2 0.0042704516129
K23 L2 L3 0.00420169354839

* Nonlinear variant: saturable_inductor_proxy
* Cubic restoring-current proxy for a saturable magnetic branch.
* Cubic restoring-current proxy for saturable magnetic branches.
.param ksat1=370.37037037
.param ksat2=81.8148148148
.param ksat3=40.3333333333
Bsat1 n1 0 I={ksat1*V(n1)*V(n1)*V(n1)}
Bsat2 n2 0 I={ksat2*V(n2)*V(n2)*V(n2)}
Bsat3 n3 0 I={ksat3*V(n3)*V(n3)*V(n3)}
* Passive soft limiter / loss proxy. Current follows voltage drop, so it dissipates.
.param gsoft12=0.000598609106708
.param gsoft23=0.000825305571377
.param vlim12=0.0677594243846
.param vlim23=0.154250874142
Bsoft12 n1 n2 I={gsoft12*V(n1,n2)*0.5*(1+tanh((abs(V(n1,n2))-vlim12)/(0.3*vlim12+1e-30)))}
Bsoft23 n2 n3 I={gsoft23*V(n2,n3)*0.5*(1+tanh((abs(V(n2,n3))-vlim23)/(0.3*vlim23+1e-30)))}

* External drives.
* source-only discovery drive: mode 1, f=1000000 Hz
.param idrive1=0.000439822971503
.param fdrive1=1000000
Bdrive1 n1 0 I={-idrive1*V(env)*sin(2*pi*fdrive1*time)}

.ic V(n1)=0 V(n2)=0 V(n3)=0
.tran {tstep} {tstop} 0 {tstep} uic
.control
set noaskquit
set wr_singlescale
set wr_vecnames
run
wrdata low_rf_412_bridge_saturable_inductor_proxy_tran.csv time v(n1) v(n2) v(n3) i(L1) i(L2) i(L3)
write low_rf_412_bridge_saturable_inductor_proxy.raw v(n1) v(n2) v(n3) i(L1) i(L2) i(L3)
quit
.endc
.end

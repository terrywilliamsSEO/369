* f008_generated_path_suppressed_generated_path_suppressed
* Forensics probes: pre-extraction raw=n96; post-extraction=v150f; source-only=True; no direct 150 MHz source.
* Hybrid purity lock-in: source-only 50 MHz, passive 150 MHz extraction.
* role=control; source_only=True; no direct 100/150 MHz discovery drive.
* extraction=single_high_q; stages=1; q_label=high
.option method=gear maxord=2 reltol=2e-4 abstol=1e-12 vntol=1e-6 chgtol=1e-16 itl4=320
.model DVAR D(Is=1e-15 Rs=0.3 Cjo=2.79001930591e-12 Vj=0.62 M=0.6 Bv=18 Ibv=1e-06)
.param kmag=4.059e-07
.param gcore=5.4e-08
Vbias vb 0 DC 12
Vsrc src 0 SIN(0 2.7 50000000)
Rsrc src n0 75
Rrawload n96 0 300
Cbase0 n0 0 1.36165577342e-11
Rbleed0 n0 0 181818.181818
Rser1 n0 ns1 0.0147887943221
Lser1 ns1 n1 7.65931372549e-08
Cfixed1 n1 0 1.19825708061e-11
Dvar1 n1 vb DVAR
Rbleed1 n1 0 181818.181818
Rser2 n1 ns2 0.0147887943221
Lser2 ns2 n2 7.65931372549e-08
Cfixed2 n2 0 1.19825708061e-11
Dvar2 n2 vb DVAR
Rbleed2 n2 0 181818.181818
Rser3 n2 ns3 0.0147887943221
Lser3 ns3 n3 7.65931372549e-08
Cfixed3 n3 0 1.19825708061e-11
Dvar3 n3 vb DVAR
Rbleed3 n3 0 181818.181818
Rser4 n3 ns4 0.0147887943221
Lser4 ns4 n4 7.65931372549e-08
Cfixed4 n4 0 1.19825708061e-11
Dvar4 n4 vb DVAR
Rbleed4 n4 0 181818.181818
Rser5 n4 ns5 0.0147887943221
Lser5 ns5 n5 7.65931372549e-08
Cfixed5 n5 0 1.19825708061e-11
Dvar5 n5 vb DVAR
Rbleed5 n5 0 181818.181818
Rser6 n5 ns6 0.0147887943221
Lser6 ns6 n6 7.65931372549e-08
Cfixed6 n6 0 1.19825708061e-11
Dvar6 n6 vb DVAR
Rbleed6 n6 0 181818.181818
Rser7 n6 ns7 0.0147887943221
Lser7 ns7 n7 7.65931372549e-08
Cfixed7 n7 0 1.19825708061e-11
Dvar7 n7 vb DVAR
Rbleed7 n7 0 181818.181818
Rser8 n7 ns8 0.0147887943221
Lser8 ns8 n8 7.65931372549e-08
Cfixed8 n8 0 1.19825708061e-11
Dvar8 n8 vb DVAR
Rbleed8 n8 0 181818.181818
Rser9 n8 ns9 0.0147887943221
Lser9 ns9 n9 7.65931372549e-08
Cfixed9 n9 0 1.19825708061e-11
Dvar9 n9 vb DVAR
Rbleed9 n9 0 181818.181818
Rser10 n9 ns10 0.0147887943221
Lser10 ns10 n10 7.65931372549e-08
Cfixed10 n10 0 1.19825708061e-11
Dvar10 n10 vb DVAR
Rbleed10 n10 0 181818.181818
Rser11 n10 ns11 0.0147887943221
Lser11 ns11 n11 7.65931372549e-08
Cfixed11 n11 0 1.19825708061e-11
Dvar11 n11 vb DVAR
Rbleed11 n11 0 181818.181818
Rser12 n11 ns12 0.0147887943221
Lser12 ns12 n12 7.65931372549e-08
Cfixed12 n12 0 1.19825708061e-11
Dvar12 n12 vb DVAR
Rbleed12 n12 0 181818.181818
Rser13 n12 ns13 0.0147887943221
Lser13 ns13 n13 7.65931372549e-08
Cfixed13 n13 0 1.19825708061e-11
Dvar13 n13 vb DVAR
Rbleed13 n13 0 181818.181818
Rser14 n13 ns14 0.0147887943221
Lser14 ns14 n14 7.65931372549e-08
Cfixed14 n14 0 1.19825708061e-11
Dvar14 n14 vb DVAR
Rbleed14 n14 0 181818.181818
Rser15 n14 ns15 0.0147887943221
Lser15 ns15 n15 7.65931372549e-08
Cfixed15 n15 0 1.19825708061e-11
Dvar15 n15 vb DVAR
Rbleed15 n15 0 181818.181818
Rser16 n15 ns16 0.0147887943221
Lser16 ns16 n16 7.65931372549e-08
Cbase16 n16 0 1.36165577342e-11
Rbleed16 n16 0 181818.181818
Rser17 n16 ns17 0.0147887943221
Lser17 ns17 n17 7.65931372549e-08
Cbase17 n17 0 1.36165577342e-11
Rbleed17 n17 0 181818.181818
Rser18 n17 ns18 0.0147887943221
Lser18 ns18 n18 7.65931372549e-08
Cbase18 n18 0 1.36165577342e-11
Rbleed18 n18 0 181818.181818
Rser19 n18 ns19 0.0147887943221
Lser19 ns19 n19 7.65931372549e-08
Cbase19 n19 0 1.36165577342e-11
Rbleed19 n19 0 181818.181818
Rser20 n19 ns20 0.0147887943221
Lser20 ns20 n20 7.65931372549e-08
Cbase20 n20 0 1.36165577342e-11
Rbleed20 n20 0 181818.181818
Rser21 n20 ns21 0.0147887943221
Lser21 ns21 n21 7.65931372549e-08
Cbase21 n21 0 1.36165577342e-11
Rbleed21 n21 0 181818.181818
Rser22 n21 ns22 0.0147887943221
Lser22 ns22 n22 7.65931372549e-08
Cbase22 n22 0 1.36165577342e-11
Rbleed22 n22 0 181818.181818
Rser23 n22 ns23 0.0147887943221
Lser23 ns23 n23 7.65931372549e-08
Cbase23 n23 0 1.36165577342e-11
Rbleed23 n23 0 181818.181818
Rser24 n23 ns24 0.0147887943221
Lser24 ns24 n24 7.65931372549e-08
Cbase24 n24 0 1.36165577342e-11
Rbleed24 n24 0 181818.181818
Rser25 n24 ns25 0.0147887943221
Lser25 ns25 n25 7.65931372549e-08
Cbase25 n25 0 1.36165577342e-11
Rbleed25 n25 0 181818.181818
Rser26 n25 ns26 0.0147887943221
Lser26 ns26 n26 7.65931372549e-08
Cbase26 n26 0 1.36165577342e-11
Rbleed26 n26 0 181818.181818
Rser27 n26 ns27 0.0147887943221
Lser27 ns27 n27 7.65931372549e-08
Cbase27 n27 0 1.36165577342e-11
Rbleed27 n27 0 181818.181818
Rser28 n27 ns28 0.0147887943221
Lser28 ns28 n28 7.65931372549e-08
Cbase28 n28 0 1.36165577342e-11
Rbleed28 n28 0 181818.181818
Rser29 n28 ns29 0.0147887943221
Lser29 ns29 n29 7.65931372549e-08
Cbase29 n29 0 1.36165577342e-11
Rbleed29 n29 0 181818.181818
Rser30 n29 ns30 0.0147887943221
Lser30 ns30 n30 7.65931372549e-08
Cbase30 n30 0 1.36165577342e-11
Rbleed30 n30 0 181818.181818
Rser31 n30 ns31 0.0147887943221
Lser31 ns31 n31 7.65931372549e-08
Cbase31 n31 0 1.36165577342e-11
Rbleed31 n31 0 181818.181818
Rser32 n31 ns32 0.0147887943221
Lser32 ns32 n32 7.65931372549e-08
Cbase32 n32 0 1.36165577342e-11
Rbleed32 n32 0 181818.181818
Rser33 n32 ns33 0.0147887943221
Lser33 ns33 n33 7.65931372549e-08
Cbase33 n33 0 1.36165577342e-11
Rbleed33 n33 0 181818.181818
Rser34 n33 ns34 0.0147887943221
Lser34 ns34 n34 7.65931372549e-08
Cbase34 n34 0 1.36165577342e-11
Rbleed34 n34 0 181818.181818
Rser35 n34 ns35 0.0147887943221
Lser35 ns35 n35 7.65931372549e-08
Cbase35 n35 0 1.36165577342e-11
Rbleed35 n35 0 181818.181818
Rser36 n35 ns36 0.0147887943221
Lser36 ns36 n36 7.65931372549e-08
Cbase36 n36 0 1.36165577342e-11
Rbleed36 n36 0 181818.181818
Rser37 n36 ns37 0.0147887943221
Lser37 ns37 n37 7.65931372549e-08
Cbase37 n37 0 1.36165577342e-11
Rbleed37 n37 0 181818.181818
Rser38 n37 ns38 0.0147887943221
Lser38 ns38 n38 7.65931372549e-08
Cbase38 n38 0 1.36165577342e-11
Rbleed38 n38 0 181818.181818
Rser39 n38 ns39 0.0147887943221
Lser39 ns39 n39 7.65931372549e-08
Cbase39 n39 0 1.36165577342e-11
Rbleed39 n39 0 181818.181818
Rser40 n39 ns40 0.0147887943221
Lser40 ns40 n40 7.65931372549e-08
Cbase40 n40 0 1.36165577342e-11
Rbleed40 n40 0 181818.181818
Rser41 n40 ns41 0.0147887943221
Lser41 ns41 n41 7.65931372549e-08
Cbase41 n41 0 1.36165577342e-11
Rbleed41 n41 0 181818.181818
Rser42 n41 ns42 0.0147887943221
Lser42 ns42 n42 7.65931372549e-08
Cbase42 n42 0 1.36165577342e-11
Rbleed42 n42 0 181818.181818
Rser43 n42 ns43 0.0147887943221
Lser43 ns43 n43 7.65931372549e-08
Cbase43 n43 0 1.36165577342e-11
Rbleed43 n43 0 181818.181818
Rser44 n43 ns44 0.0147887943221
Lser44 ns44 n44 7.65931372549e-08
Cbase44 n44 0 1.36165577342e-11
Rbleed44 n44 0 181818.181818
Rser45 n44 ns45 0.0147887943221
Lser45 ns45 n45 7.65931372549e-08
Cbase45 n45 0 1.36165577342e-11
Rbleed45 n45 0 181818.181818
Rser46 n45 ns46 0.0147887943221
Lser46 ns46 n46 7.65931372549e-08
Cbase46 n46 0 1.36165577342e-11
Rbleed46 n46 0 181818.181818
Rser47 n46 ns47 0.0147887943221
Lser47 ns47 n47 7.65931372549e-08
Cbase47 n47 0 1.36165577342e-11
Rbleed47 n47 0 181818.181818
Rser48 n47 ns48 0.0147887943221
Lser48 ns48 n48 7.65931372549e-08
Cbase48 n48 0 1.36165577342e-11
Rbleed48 n48 0 181818.181818
Rser49 n48 ns49 0.0147887943221
Lser49 ns49 n49 7.65931372549e-08
Cbase49 n49 0 1.36165577342e-11
Rbleed49 n49 0 181818.181818
Rser50 n49 ns50 0.0147887943221
Lser50 ns50 n50 7.65931372549e-08
Cbase50 n50 0 1.36165577342e-11
Rbleed50 n50 0 181818.181818
Rser51 n50 ns51 0.0147887943221
Lser51 ns51 n51 7.65931372549e-08
Cbase51 n51 0 1.36165577342e-11
Rbleed51 n51 0 181818.181818
Rser52 n51 ns52 0.0147887943221
Lser52 ns52 n52 7.65931372549e-08
Cbase52 n52 0 1.36165577342e-11
Rbleed52 n52 0 181818.181818
Rser53 n52 ns53 0.0147887943221
Lser53 ns53 n53 7.65931372549e-08
Cbase53 n53 0 1.36165577342e-11
Rbleed53 n53 0 181818.181818
Rser54 n53 ns54 0.0147887943221
Lser54 ns54 n54 7.65931372549e-08
Cbase54 n54 0 1.36165577342e-11
Rbleed54 n54 0 181818.181818
Rser55 n54 ns55 0.0147887943221
Lser55 ns55 n55 7.65931372549e-08
Cbase55 n55 0 1.36165577342e-11
Rbleed55 n55 0 181818.181818
Rser56 n55 ns56 0.0147887943221
Lser56 ns56 n56 7.65931372549e-08
Cbase56 n56 0 1.36165577342e-11
Rbleed56 n56 0 181818.181818
Rser57 n56 ns57 0.0147887943221
Lser57 ns57 n57 7.65931372549e-08
Cbase57 n57 0 1.36165577342e-11
Rbleed57 n57 0 181818.181818
Rser58 n57 ns58 0.0147887943221
Lser58 ns58 n58 7.65931372549e-08
Cbase58 n58 0 1.36165577342e-11
Rbleed58 n58 0 181818.181818
Rser59 n58 ns59 0.0147887943221
Lser59 ns59 n59 7.65931372549e-08
Cbase59 n59 0 1.36165577342e-11
Rbleed59 n59 0 181818.181818
Rser60 n59 ns60 0.0147887943221
Lser60 ns60 n60 7.65931372549e-08
Cbase60 n60 0 1.36165577342e-11
Rbleed60 n60 0 181818.181818
Rser61 n60 ns61 0.0147887943221
Lser61 ns61 n61 7.65931372549e-08
Cbase61 n61 0 1.36165577342e-11
Rbleed61 n61 0 181818.181818
Rser62 n61 ns62 0.0147887943221
Lser62 ns62 n62 7.65931372549e-08
Cbase62 n62 0 1.36165577342e-11
Rbleed62 n62 0 181818.181818
Rser63 n62 ns63 0.0147887943221
Lser63 ns63 n63 7.65931372549e-08
Cbase63 n63 0 1.36165577342e-11
Rbleed63 n63 0 181818.181818
Rser64 n63 ns64 0.0147887943221
Lser64 ns64 n64 7.65931372549e-08
Cbase64 n64 0 1.36165577342e-11
Rbleed64 n64 0 181818.181818
Rser65 n64 ns65 0.0147887943221
Lser65 ns65 n65 7.65931372549e-08
Cbase65 n65 0 1.36165577342e-11
Rbleed65 n65 0 181818.181818
Rser66 n65 ns66 0.0147887943221
Lser66 ns66 n66 7.65931372549e-08
Cbase66 n66 0 1.36165577342e-11
Rbleed66 n66 0 181818.181818
Rser67 n66 ns67 0.0147887943221
Lser67 ns67 n67 7.65931372549e-08
Cbase67 n67 0 1.36165577342e-11
Rbleed67 n67 0 181818.181818
Rser68 n67 ns68 0.0147887943221
Lser68 ns68 n68 7.65931372549e-08
Cbase68 n68 0 1.36165577342e-11
Rbleed68 n68 0 181818.181818
Rser69 n68 ns69 0.0147887943221
Lser69 ns69 n69 7.65931372549e-08
Cbase69 n69 0 1.36165577342e-11
Rbleed69 n69 0 181818.181818
Rser70 n69 ns70 0.0147887943221
Lser70 ns70 n70 7.65931372549e-08
Cbase70 n70 0 1.36165577342e-11
Rbleed70 n70 0 181818.181818
Rser71 n70 ns71 0.0147887943221
Lser71 ns71 n71 7.65931372549e-08
Cbase71 n71 0 1.36165577342e-11
Rbleed71 n71 0 181818.181818
Rser72 n71 ns72 0.0147887943221
Lser72 ns72 n72 7.65931372549e-08
Cbase72 n72 0 1.36165577342e-11
Rbleed72 n72 0 181818.181818
Rser73 n72 ns73 0.0147887943221
Lser73 ns73 n73 7.65931372549e-08
Cbase73 n73 0 1.36165577342e-11
Rbleed73 n73 0 181818.181818
Rser74 n73 ns74 0.0147887943221
Lser74 ns74 n74 7.65931372549e-08
Cbase74 n74 0 1.36165577342e-11
Rbleed74 n74 0 181818.181818
Rser75 n74 ns75 0.0147887943221
Lser75 ns75 n75 7.65931372549e-08
Cbase75 n75 0 1.36165577342e-11
Rbleed75 n75 0 181818.181818
Rser76 n75 ns76 0.0147887943221
Lser76 ns76 n76 7.65931372549e-08
Cbase76 n76 0 1.36165577342e-11
Rbleed76 n76 0 181818.181818
Rser77 n76 ns77 0.0147887943221
Lser77 ns77 n77 7.65931372549e-08
Cbase77 n77 0 1.36165577342e-11
Rbleed77 n77 0 181818.181818
Rser78 n77 ns78 0.0147887943221
Lser78 ns78 n78 7.65931372549e-08
Cbase78 n78 0 1.36165577342e-11
Rbleed78 n78 0 181818.181818
Rser79 n78 ns79 0.0147887943221
Lser79 ns79 n79 7.65931372549e-08
Cbase79 n79 0 1.36165577342e-11
Rbleed79 n79 0 181818.181818
Rser80 n79 ns80 0.0147887943221
Lser80 ns80 n80 7.65931372549e-08
Cbase80 n80 0 1.36165577342e-11
Rbleed80 n80 0 181818.181818
Rser81 n80 ns81 0.0147887943221
Lser81 ns81 n81 7.65931372549e-08
Cbase81 n81 0 1.36165577342e-11
Rbleed81 n81 0 181818.181818
Rser82 n81 ns82 0.0147887943221
Lser82 ns82 n82 7.65931372549e-08
Cbase82 n82 0 1.36165577342e-11
Rbleed82 n82 0 181818.181818
Rser83 n82 ns83 0.0147887943221
Lser83 ns83 n83 7.65931372549e-08
Cbase83 n83 0 1.36165577342e-11
Rbleed83 n83 0 181818.181818
Rser84 n83 ns84 0.0147887943221
Lser84 ns84 n84 7.65931372549e-08
Cbase84 n84 0 1.36165577342e-11
Rbleed84 n84 0 181818.181818
Rser85 n84 ns85 0.0147887943221
Lser85 ns85 n85 7.65931372549e-08
Cbase85 n85 0 1.36165577342e-11
Rbleed85 n85 0 181818.181818
Rser86 n85 ns86 0.0147887943221
Lser86 ns86 n86 7.65931372549e-08
Cbase86 n86 0 1.36165577342e-11
Rbleed86 n86 0 181818.181818
Rser87 n86 ns87 0.0147887943221
Lser87 ns87 n87 7.65931372549e-08
Cbase87 n87 0 1.36165577342e-11
Rbleed87 n87 0 181818.181818
Rser88 n87 ns88 0.0147887943221
Lser88 ns88 n88 7.65931372549e-08
Cbase88 n88 0 1.36165577342e-11
Rbleed88 n88 0 181818.181818
Rser89 n88 ns89 0.0147887943221
Lser89 ns89 n89 7.65931372549e-08
Cbase89 n89 0 1.36165577342e-11
Rbleed89 n89 0 181818.181818
Rser90 n89 ns90 0.0147887943221
Lser90 ns90 n90 7.65931372549e-08
Cbase90 n90 0 1.36165577342e-11
Rbleed90 n90 0 181818.181818
Rser91 n90 ns91 0.0147887943221
Lser91 ns91 n91 7.65931372549e-08
Cbase91 n91 0 1.36165577342e-11
Rbleed91 n91 0 181818.181818
Rser92 n91 ns92 0.0147887943221
Lser92 ns92 n92 7.65931372549e-08
Cbase92 n92 0 1.36165577342e-11
Rbleed92 n92 0 181818.181818
Rser93 n92 ns93 0.0147887943221
Lser93 ns93 n93 7.65931372549e-08
Cbase93 n93 0 1.36165577342e-11
Rbleed93 n93 0 181818.181818
Rser94 n93 ns94 0.0147887943221
Lser94 ns94 n94 7.65931372549e-08
Cbase94 n94 0 1.36165577342e-11
Rbleed94 n94 0 181818.181818
Rser95 n94 ns95 0.0147887943221
Lser95 ns95 n95 7.65931372549e-08
Cbase95 n95 0 1.36165577342e-11
Rbleed95 n95 0 181818.181818
Rser96 n95 ns96 0.0147887943221
Lser96 ns96 n96 7.65931372549e-08
Cbase96 n96 0 1.36165577342e-11
Rbleed96 n96 0 181818.181818
Bmag60 n60 0 I={(1.12314262106)*kmag*V(n60)*V(n60)*V(n60)/(1+(V(n60)/7.5)**2) + gcore*V(n60)}
Bmag64 n64 0 I={(1.12581004373)*kmag*V(n64)*V(n64)*V(n64)/(1+(V(n64)/7.5)**2) + gcore*V(n64)}
Bmag68 n68 0 I={(1.12825907778)*kmag*V(n68)*V(n68)*V(n68)/(1+(V(n68)/7.5)**2) + gcore*V(n68)}
Bmag72 n72 0 I={(1.13048547204)*kmag*V(n72)*V(n72)*V(n72)/(1+(V(n72)/7.5)**2) + gcore*V(n72)}
Bmag76 n76 0 I={(1.13248536179)*kmag*V(n76)*V(n76)*V(n76)/(1+(V(n76)/7.5)**2) + gcore*V(n76)}
Bmag80 n80 0 I={(1.1342552755)*kmag*V(n80)*V(n80)*V(n80)/(1+(V(n80)/7.5)**2) + gcore*V(n80)}
Bmag84 n84 0 I={(1.13579214086)*kmag*V(n84)*V(n84)*V(n84)/(1+(V(n84)/7.5)**2) + gcore*V(n84)}
Bmag88 n88 0 I={(1.13709329008)*kmag*V(n88)*V(n88)*V(n88)/(1+(V(n88)/7.5)**2) + gcore*V(n88)}
Bmag92 n92 0 I={(1.13815646455)*kmag*V(n92)*V(n92)*V(n92)/(1+(V(n92)/7.5)**2) + gcore*V(n92)}
Bmag96 n96 0 I={(1.13897981875)*kmag*V(n96)*V(n96)*V(n96)/(1+(V(n96)/7.5)**2) + gcore*V(n96)}
Rlock50 n96 lk50r 21.5657104461
Llock50 lk50r lk50l 1.23562419076e-06
Clock50 lk50l 0 8.2e-12
Rlock100 n96 lk100r 18.7647310757
Llock100 lk100r lk100l 7.07328877853e-07
Clock100 lk100l 0 6.2e-12
Rext1 n96 ext1r 8.23706862271
Lext1 ext1r ext1l 2.42918947202e-07
Cext1 ext1l v150 4.7e-12
Rload150_1 v150 0 100
Rpost150 v150 post150r 8.25115834536
Lpost150 post150r post150l 6.30342065711e-07
Cpost150 post150l v150f 1.786e-12
Rload150f v150f 0 207.5
.control
set filetype=ascii
set wr_singlescale
set wr_vecnames
tran 5e-10 5.5e-07 0 2e-10
wrdata f008_generated_path_suppressed_generated_path_suppressed_tran.csv time v(n0) v(n24) v(n48) v(n72) v(n96) v(v150f) i(Vsrc) i(Vbias)
.endc
.end

* h019_alternating_varactor_magnetic_cells_128c_100ohm
* Hybrid varactor-plus-magnetic 50/100/150 MHz refinement track.
* role=discovery; source_only=True; no direct 100/150 MHz discovery drive.
* placement=alternating_varactor_magnetic_cells; magnetic_curve=soft; cleanup=extraction_plus_rejection
.option method=gear maxord=2 reltol=2e-4 abstol=1e-12 vntol=1e-6 chgtol=1e-16 itl4=280
.model DVAR D(Is=1e-15 Rs=0.34 Cjo=3.666533441e-11 Vj=0.65 M=0.58 Bv=18 Ibv=1e-06)
.param kmag=1.599e-06
.param gcore=1.5e-07
Vbias vb 0 DC 3.4
Vsrc src 0 SIN(0 2.15 50000000)
Rsrc src n0 100
Rrawload n128 0 300
Cbase0 n0 0 1.14623552124e-11
Rbleed0 n0 0 160000
Rser1 n0 ns1 0.0134571259295
Lser1 ns1 n1 1.14623552124e-07
Cfixed1 n1 0 1.96006274131e-12
Dvar1a n1 vst1 DVAR
Dvar1b vst1 vb DVAR
Rstack1 vst1 vb 2000000
Rbleed1 n1 0 160000
Rser2 n1 ns2 0.0134571259295
Lser2 ns2 n2 1.14623552124e-07
Cfixed2 n2 0 1.96006274131e-12
Dvar2a n2 vst2 DVAR
Dvar2b vst2 vb DVAR
Rstack2 vst2 vb 2000000
Rbleed2 n2 0 160000
Rser3 n2 ns3 0.0134571259295
Lser3 ns3 n3 1.14623552124e-07
Cfixed3 n3 0 1.96006274131e-12
Dvar3a n3 vst3 DVAR
Dvar3b vst3 vb DVAR
Rstack3 vst3 vb 2000000
Rbleed3 n3 0 160000
Rser4 n3 ns4 0.0134571259295
Lser4 ns4 n4 1.14623552124e-07
Cfixed4 n4 0 1.96006274131e-12
Dvar4a n4 vst4 DVAR
Dvar4b vst4 vb DVAR
Rstack4 vst4 vb 2000000
Rbleed4 n4 0 160000
Rser5 n4 ns5 0.0134571259295
Lser5 ns5 n5 1.14623552124e-07
Cfixed5 n5 0 1.96006274131e-12
Dvar5a n5 vst5 DVAR
Dvar5b vst5 vb DVAR
Rstack5 vst5 vb 2000000
Rbleed5 n5 0 160000
Rser6 n5 ns6 0.0134571259295
Lser6 ns6 n6 1.14623552124e-07
Cfixed6 n6 0 1.96006274131e-12
Dvar6a n6 vst6 DVAR
Dvar6b vst6 vb DVAR
Rstack6 vst6 vb 2000000
Rbleed6 n6 0 160000
Rser7 n6 ns7 0.0134571259295
Lser7 ns7 n7 1.14623552124e-07
Cfixed7 n7 0 1.96006274131e-12
Dvar7a n7 vst7 DVAR
Dvar7b vst7 vb DVAR
Rstack7 vst7 vb 2000000
Rbleed7 n7 0 160000
Rser8 n7 ns8 0.0134571259295
Lser8 ns8 n8 1.14623552124e-07
Cfixed8 n8 0 1.96006274131e-12
Dvar8a n8 vst8 DVAR
Dvar8b vst8 vb DVAR
Rstack8 vst8 vb 2000000
Rbleed8 n8 0 160000
Rser9 n8 ns9 0.0134571259295
Lser9 ns9 n9 1.14623552124e-07
Cfixed9 n9 0 1.96006274131e-12
Dvar9a n9 vst9 DVAR
Dvar9b vst9 vb DVAR
Rstack9 vst9 vb 2000000
Rbleed9 n9 0 160000
Rser10 n9 ns10 0.0134571259295
Lser10 ns10 n10 1.14623552124e-07
Cfixed10 n10 0 1.96006274131e-12
Dvar10a n10 vst10 DVAR
Dvar10b vst10 vb DVAR
Rstack10 vst10 vb 2000000
Rbleed10 n10 0 160000
Rser11 n10 ns11 0.0134571259295
Lser11 ns11 n11 1.14623552124e-07
Cfixed11 n11 0 1.96006274131e-12
Dvar11a n11 vst11 DVAR
Dvar11b vst11 vb DVAR
Rstack11 vst11 vb 2000000
Rbleed11 n11 0 160000
Rser12 n11 ns12 0.0134571259295
Lser12 ns12 n12 1.14623552124e-07
Cfixed12 n12 0 1.96006274131e-12
Dvar12a n12 vst12 DVAR
Dvar12b vst12 vb DVAR
Rstack12 vst12 vb 2000000
Rbleed12 n12 0 160000
Rser13 n12 ns13 0.0134571259295
Lser13 ns13 n13 1.14623552124e-07
Cfixed13 n13 0 1.96006274131e-12
Dvar13a n13 vst13 DVAR
Dvar13b vst13 vb DVAR
Rstack13 vst13 vb 2000000
Rbleed13 n13 0 160000
Rser14 n13 ns14 0.0134571259295
Lser14 ns14 n14 1.14623552124e-07
Cfixed14 n14 0 1.96006274131e-12
Dvar14a n14 vst14 DVAR
Dvar14b vst14 vb DVAR
Rstack14 vst14 vb 2000000
Rbleed14 n14 0 160000
Rser15 n14 ns15 0.0134571259295
Lser15 ns15 n15 1.14623552124e-07
Cfixed15 n15 0 1.96006274131e-12
Dvar15a n15 vst15 DVAR
Dvar15b vst15 vb DVAR
Rstack15 vst15 vb 2000000
Rbleed15 n15 0 160000
Rser16 n15 ns16 0.0134571259295
Lser16 ns16 n16 1.14623552124e-07
Cfixed16 n16 0 1.96006274131e-12
Dvar16a n16 vst16 DVAR
Dvar16b vst16 vb DVAR
Rstack16 vst16 vb 2000000
Rbleed16 n16 0 160000
Rser17 n16 ns17 0.0134571259295
Lser17 ns17 n17 1.14623552124e-07
Cfixed17 n17 0 1.96006274131e-12
Dvar17a n17 vst17 DVAR
Dvar17b vst17 vb DVAR
Rstack17 vst17 vb 2000000
Rbleed17 n17 0 160000
Rser18 n17 ns18 0.0134571259295
Lser18 ns18 n18 1.14623552124e-07
Cfixed18 n18 0 1.96006274131e-12
Dvar18a n18 vst18 DVAR
Dvar18b vst18 vb DVAR
Rstack18 vst18 vb 2000000
Rbleed18 n18 0 160000
Rser19 n18 ns19 0.0134571259295
Lser19 ns19 n19 1.14623552124e-07
Cfixed19 n19 0 1.96006274131e-12
Dvar19a n19 vst19 DVAR
Dvar19b vst19 vb DVAR
Rstack19 vst19 vb 2000000
Rbleed19 n19 0 160000
Rser20 n19 ns20 0.0134571259295
Lser20 ns20 n20 1.14623552124e-07
Cfixed20 n20 0 1.96006274131e-12
Dvar20a n20 vst20 DVAR
Dvar20b vst20 vb DVAR
Rstack20 vst20 vb 2000000
Rbleed20 n20 0 160000
Rser21 n20 ns21 0.0134571259295
Lser21 ns21 n21 1.14623552124e-07
Cfixed21 n21 0 1.96006274131e-12
Dvar21a n21 vst21 DVAR
Dvar21b vst21 vb DVAR
Rstack21 vst21 vb 2000000
Rbleed21 n21 0 160000
Rser22 n21 ns22 0.0134571259295
Lser22 ns22 n22 1.14623552124e-07
Cfixed22 n22 0 1.96006274131e-12
Dvar22a n22 vst22 DVAR
Dvar22b vst22 vb DVAR
Rstack22 vst22 vb 2000000
Rbleed22 n22 0 160000
Rser23 n22 ns23 0.0134571259295
Lser23 ns23 n23 1.14623552124e-07
Cfixed23 n23 0 1.96006274131e-12
Dvar23a n23 vst23 DVAR
Dvar23b vst23 vb DVAR
Rstack23 vst23 vb 2000000
Rbleed23 n23 0 160000
Rser24 n23 ns24 0.0134571259295
Lser24 ns24 n24 1.14623552124e-07
Cfixed24 n24 0 1.96006274131e-12
Dvar24a n24 vst24 DVAR
Dvar24b vst24 vb DVAR
Rstack24 vst24 vb 2000000
Rbleed24 n24 0 160000
Rser25 n24 ns25 0.0134571259295
Lser25 ns25 n25 1.14623552124e-07
Cfixed25 n25 0 1.96006274131e-12
Dvar25a n25 vst25 DVAR
Dvar25b vst25 vb DVAR
Rstack25 vst25 vb 2000000
Rbleed25 n25 0 160000
Rser26 n25 ns26 0.0134571259295
Lser26 ns26 n26 1.14623552124e-07
Cfixed26 n26 0 1.96006274131e-12
Dvar26a n26 vst26 DVAR
Dvar26b vst26 vb DVAR
Rstack26 vst26 vb 2000000
Rbleed26 n26 0 160000
Rser27 n26 ns27 0.0134571259295
Lser27 ns27 n27 1.14623552124e-07
Cfixed27 n27 0 1.96006274131e-12
Dvar27a n27 vst27 DVAR
Dvar27b vst27 vb DVAR
Rstack27 vst27 vb 2000000
Rbleed27 n27 0 160000
Rser28 n27 ns28 0.0134571259295
Lser28 ns28 n28 1.14623552124e-07
Cfixed28 n28 0 1.96006274131e-12
Dvar28a n28 vst28 DVAR
Dvar28b vst28 vb DVAR
Rstack28 vst28 vb 2000000
Rbleed28 n28 0 160000
Rser29 n28 ns29 0.0134571259295
Lser29 ns29 n29 1.14623552124e-07
Cfixed29 n29 0 1.96006274131e-12
Dvar29a n29 vst29 DVAR
Dvar29b vst29 vb DVAR
Rstack29 vst29 vb 2000000
Rbleed29 n29 0 160000
Rser30 n29 ns30 0.0134571259295
Lser30 ns30 n30 1.14623552124e-07
Cfixed30 n30 0 1.96006274131e-12
Dvar30a n30 vst30 DVAR
Dvar30b vst30 vb DVAR
Rstack30 vst30 vb 2000000
Rbleed30 n30 0 160000
Rser31 n30 ns31 0.0134571259295
Lser31 ns31 n31 1.14623552124e-07
Cfixed31 n31 0 1.96006274131e-12
Dvar31a n31 vst31 DVAR
Dvar31b vst31 vb DVAR
Rstack31 vst31 vb 2000000
Rbleed31 n31 0 160000
Rser32 n31 ns32 0.0134571259295
Lser32 ns32 n32 1.14623552124e-07
Cfixed32 n32 0 1.96006274131e-12
Dvar32a n32 vst32 DVAR
Dvar32b vst32 vb DVAR
Rstack32 vst32 vb 2000000
Rbleed32 n32 0 160000
Rser33 n32 ns33 0.0134571259295
Lser33 ns33 n33 1.14623552124e-07
Cfixed33 n33 0 1.96006274131e-12
Dvar33a n33 vst33 DVAR
Dvar33b vst33 vb DVAR
Rstack33 vst33 vb 2000000
Rbleed33 n33 0 160000
Rser34 n33 ns34 0.0134571259295
Lser34 ns34 n34 1.14623552124e-07
Cfixed34 n34 0 1.96006274131e-12
Dvar34a n34 vst34 DVAR
Dvar34b vst34 vb DVAR
Rstack34 vst34 vb 2000000
Rbleed34 n34 0 160000
Rser35 n34 ns35 0.0134571259295
Lser35 ns35 n35 1.14623552124e-07
Cfixed35 n35 0 1.96006274131e-12
Dvar35a n35 vst35 DVAR
Dvar35b vst35 vb DVAR
Rstack35 vst35 vb 2000000
Rbleed35 n35 0 160000
Rser36 n35 ns36 0.0134571259295
Lser36 ns36 n36 1.14623552124e-07
Cfixed36 n36 0 1.96006274131e-12
Dvar36a n36 vst36 DVAR
Dvar36b vst36 vb DVAR
Rstack36 vst36 vb 2000000
Rbleed36 n36 0 160000
Rser37 n36 ns37 0.0134571259295
Lser37 ns37 n37 1.14623552124e-07
Cfixed37 n37 0 1.96006274131e-12
Dvar37a n37 vst37 DVAR
Dvar37b vst37 vb DVAR
Rstack37 vst37 vb 2000000
Rbleed37 n37 0 160000
Rser38 n37 ns38 0.0134571259295
Lser38 ns38 n38 1.14623552124e-07
Cfixed38 n38 0 1.96006274131e-12
Dvar38a n38 vst38 DVAR
Dvar38b vst38 vb DVAR
Rstack38 vst38 vb 2000000
Rbleed38 n38 0 160000
Rser39 n38 ns39 0.0134571259295
Lser39 ns39 n39 1.14623552124e-07
Cfixed39 n39 0 1.96006274131e-12
Dvar39a n39 vst39 DVAR
Dvar39b vst39 vb DVAR
Rstack39 vst39 vb 2000000
Rbleed39 n39 0 160000
Rser40 n39 ns40 0.0134571259295
Lser40 ns40 n40 1.14623552124e-07
Cfixed40 n40 0 1.96006274131e-12
Dvar40a n40 vst40 DVAR
Dvar40b vst40 vb DVAR
Rstack40 vst40 vb 2000000
Rbleed40 n40 0 160000
Rser41 n40 ns41 0.0134571259295
Lser41 ns41 n41 1.14623552124e-07
Cfixed41 n41 0 1.96006274131e-12
Dvar41a n41 vst41 DVAR
Dvar41b vst41 vb DVAR
Rstack41 vst41 vb 2000000
Rbleed41 n41 0 160000
Rser42 n41 ns42 0.0134571259295
Lser42 ns42 n42 1.14623552124e-07
Cfixed42 n42 0 1.96006274131e-12
Dvar42a n42 vst42 DVAR
Dvar42b vst42 vb DVAR
Rstack42 vst42 vb 2000000
Rbleed42 n42 0 160000
Rser43 n42 ns43 0.0134571259295
Lser43 ns43 n43 1.14623552124e-07
Cfixed43 n43 0 1.96006274131e-12
Dvar43a n43 vst43 DVAR
Dvar43b vst43 vb DVAR
Rstack43 vst43 vb 2000000
Rbleed43 n43 0 160000
Rser44 n43 ns44 0.0134571259295
Lser44 ns44 n44 1.14623552124e-07
Cfixed44 n44 0 1.96006274131e-12
Dvar44a n44 vst44 DVAR
Dvar44b vst44 vb DVAR
Rstack44 vst44 vb 2000000
Rbleed44 n44 0 160000
Rser45 n44 ns45 0.0134571259295
Lser45 ns45 n45 1.14623552124e-07
Cfixed45 n45 0 1.96006274131e-12
Dvar45a n45 vst45 DVAR
Dvar45b vst45 vb DVAR
Rstack45 vst45 vb 2000000
Rbleed45 n45 0 160000
Rser46 n45 ns46 0.0134571259295
Lser46 ns46 n46 1.14623552124e-07
Cfixed46 n46 0 1.96006274131e-12
Dvar46a n46 vst46 DVAR
Dvar46b vst46 vb DVAR
Rstack46 vst46 vb 2000000
Rbleed46 n46 0 160000
Rser47 n46 ns47 0.0134571259295
Lser47 ns47 n47 1.14623552124e-07
Cfixed47 n47 0 1.96006274131e-12
Dvar47a n47 vst47 DVAR
Dvar47b vst47 vb DVAR
Rstack47 vst47 vb 2000000
Rbleed47 n47 0 160000
Rser48 n47 ns48 0.0134571259295
Lser48 ns48 n48 1.14623552124e-07
Cfixed48 n48 0 1.96006274131e-12
Dvar48a n48 vst48 DVAR
Dvar48b vst48 vb DVAR
Rstack48 vst48 vb 2000000
Rbleed48 n48 0 160000
Rser49 n48 ns49 0.0134571259295
Lser49 ns49 n49 1.14623552124e-07
Cfixed49 n49 0 1.96006274131e-12
Dvar49a n49 vst49 DVAR
Dvar49b vst49 vb DVAR
Rstack49 vst49 vb 2000000
Rbleed49 n49 0 160000
Rser50 n49 ns50 0.0134571259295
Lser50 ns50 n50 1.14623552124e-07
Cfixed50 n50 0 1.96006274131e-12
Dvar50a n50 vst50 DVAR
Dvar50b vst50 vb DVAR
Rstack50 vst50 vb 2000000
Rbleed50 n50 0 160000
Rser51 n50 ns51 0.0134571259295
Lser51 ns51 n51 1.14623552124e-07
Cfixed51 n51 0 1.96006274131e-12
Dvar51a n51 vst51 DVAR
Dvar51b vst51 vb DVAR
Rstack51 vst51 vb 2000000
Rbleed51 n51 0 160000
Rser52 n51 ns52 0.0134571259295
Lser52 ns52 n52 1.14623552124e-07
Cfixed52 n52 0 1.96006274131e-12
Dvar52a n52 vst52 DVAR
Dvar52b vst52 vb DVAR
Rstack52 vst52 vb 2000000
Rbleed52 n52 0 160000
Rser53 n52 ns53 0.0134571259295
Lser53 ns53 n53 1.14623552124e-07
Cfixed53 n53 0 1.96006274131e-12
Dvar53a n53 vst53 DVAR
Dvar53b vst53 vb DVAR
Rstack53 vst53 vb 2000000
Rbleed53 n53 0 160000
Rser54 n53 ns54 0.0134571259295
Lser54 ns54 n54 1.14623552124e-07
Cfixed54 n54 0 1.96006274131e-12
Dvar54a n54 vst54 DVAR
Dvar54b vst54 vb DVAR
Rstack54 vst54 vb 2000000
Rbleed54 n54 0 160000
Rser55 n54 ns55 0.0134571259295
Lser55 ns55 n55 1.14623552124e-07
Cfixed55 n55 0 1.96006274131e-12
Dvar55a n55 vst55 DVAR
Dvar55b vst55 vb DVAR
Rstack55 vst55 vb 2000000
Rbleed55 n55 0 160000
Rser56 n55 ns56 0.0134571259295
Lser56 ns56 n56 1.14623552124e-07
Cfixed56 n56 0 1.96006274131e-12
Dvar56a n56 vst56 DVAR
Dvar56b vst56 vb DVAR
Rstack56 vst56 vb 2000000
Rbleed56 n56 0 160000
Rser57 n56 ns57 0.0134571259295
Lser57 ns57 n57 1.14623552124e-07
Cfixed57 n57 0 1.96006274131e-12
Dvar57a n57 vst57 DVAR
Dvar57b vst57 vb DVAR
Rstack57 vst57 vb 2000000
Rbleed57 n57 0 160000
Rser58 n57 ns58 0.0134571259295
Lser58 ns58 n58 1.14623552124e-07
Cfixed58 n58 0 1.96006274131e-12
Dvar58a n58 vst58 DVAR
Dvar58b vst58 vb DVAR
Rstack58 vst58 vb 2000000
Rbleed58 n58 0 160000
Rser59 n58 ns59 0.0134571259295
Lser59 ns59 n59 1.14623552124e-07
Cfixed59 n59 0 1.96006274131e-12
Dvar59a n59 vst59 DVAR
Dvar59b vst59 vb DVAR
Rstack59 vst59 vb 2000000
Rbleed59 n59 0 160000
Rser60 n59 ns60 0.0134571259295
Lser60 ns60 n60 1.14623552124e-07
Cfixed60 n60 0 1.96006274131e-12
Dvar60a n60 vst60 DVAR
Dvar60b vst60 vb DVAR
Rstack60 vst60 vb 2000000
Rbleed60 n60 0 160000
Rser61 n60 ns61 0.0134571259295
Lser61 ns61 n61 1.14623552124e-07
Cfixed61 n61 0 1.96006274131e-12
Dvar61a n61 vst61 DVAR
Dvar61b vst61 vb DVAR
Rstack61 vst61 vb 2000000
Rbleed61 n61 0 160000
Rser62 n61 ns62 0.0134571259295
Lser62 ns62 n62 1.14623552124e-07
Cfixed62 n62 0 1.96006274131e-12
Dvar62a n62 vst62 DVAR
Dvar62b vst62 vb DVAR
Rstack62 vst62 vb 2000000
Rbleed62 n62 0 160000
Rser63 n62 ns63 0.0134571259295
Lser63 ns63 n63 1.14623552124e-07
Cfixed63 n63 0 1.96006274131e-12
Dvar63a n63 vst63 DVAR
Dvar63b vst63 vb DVAR
Rstack63 vst63 vb 2000000
Rbleed63 n63 0 160000
Rser64 n63 ns64 0.0134571259295
Lser64 ns64 n64 1.14623552124e-07
Cfixed64 n64 0 1.96006274131e-12
Dvar64a n64 vst64 DVAR
Dvar64b vst64 vb DVAR
Rstack64 vst64 vb 2000000
Rbleed64 n64 0 160000
Rser65 n64 ns65 0.0134571259295
Lser65 ns65 n65 1.14623552124e-07
Cfixed65 n65 0 1.96006274131e-12
Dvar65a n65 vst65 DVAR
Dvar65b vst65 vb DVAR
Rstack65 vst65 vb 2000000
Rbleed65 n65 0 160000
Rser66 n65 ns66 0.0134571259295
Lser66 ns66 n66 1.14623552124e-07
Cfixed66 n66 0 1.96006274131e-12
Dvar66a n66 vst66 DVAR
Dvar66b vst66 vb DVAR
Rstack66 vst66 vb 2000000
Rbleed66 n66 0 160000
Rser67 n66 ns67 0.0134571259295
Lser67 ns67 n67 1.14623552124e-07
Cfixed67 n67 0 1.96006274131e-12
Dvar67a n67 vst67 DVAR
Dvar67b vst67 vb DVAR
Rstack67 vst67 vb 2000000
Rbleed67 n67 0 160000
Rser68 n67 ns68 0.0134571259295
Lser68 ns68 n68 1.14623552124e-07
Cfixed68 n68 0 1.96006274131e-12
Dvar68a n68 vst68 DVAR
Dvar68b vst68 vb DVAR
Rstack68 vst68 vb 2000000
Rbleed68 n68 0 160000
Rser69 n68 ns69 0.0134571259295
Lser69 ns69 n69 1.14623552124e-07
Cfixed69 n69 0 1.96006274131e-12
Dvar69a n69 vst69 DVAR
Dvar69b vst69 vb DVAR
Rstack69 vst69 vb 2000000
Rbleed69 n69 0 160000
Rser70 n69 ns70 0.0134571259295
Lser70 ns70 n70 1.14623552124e-07
Cfixed70 n70 0 1.96006274131e-12
Dvar70a n70 vst70 DVAR
Dvar70b vst70 vb DVAR
Rstack70 vst70 vb 2000000
Rbleed70 n70 0 160000
Rser71 n70 ns71 0.0134571259295
Lser71 ns71 n71 1.14623552124e-07
Cfixed71 n71 0 1.96006274131e-12
Dvar71a n71 vst71 DVAR
Dvar71b vst71 vb DVAR
Rstack71 vst71 vb 2000000
Rbleed71 n71 0 160000
Rser72 n71 ns72 0.0134571259295
Lser72 ns72 n72 1.14623552124e-07
Cfixed72 n72 0 1.96006274131e-12
Dvar72a n72 vst72 DVAR
Dvar72b vst72 vb DVAR
Rstack72 vst72 vb 2000000
Rbleed72 n72 0 160000
Rser73 n72 ns73 0.0134571259295
Lser73 ns73 n73 1.14623552124e-07
Cfixed73 n73 0 1.96006274131e-12
Dvar73a n73 vst73 DVAR
Dvar73b vst73 vb DVAR
Rstack73 vst73 vb 2000000
Rbleed73 n73 0 160000
Rser74 n73 ns74 0.0134571259295
Lser74 ns74 n74 1.14623552124e-07
Cfixed74 n74 0 1.96006274131e-12
Dvar74a n74 vst74 DVAR
Dvar74b vst74 vb DVAR
Rstack74 vst74 vb 2000000
Rbleed74 n74 0 160000
Rser75 n74 ns75 0.0134571259295
Lser75 ns75 n75 1.14623552124e-07
Cfixed75 n75 0 1.96006274131e-12
Dvar75a n75 vst75 DVAR
Dvar75b vst75 vb DVAR
Rstack75 vst75 vb 2000000
Rbleed75 n75 0 160000
Rser76 n75 ns76 0.0134571259295
Lser76 ns76 n76 1.14623552124e-07
Cfixed76 n76 0 1.96006274131e-12
Dvar76a n76 vst76 DVAR
Dvar76b vst76 vb DVAR
Rstack76 vst76 vb 2000000
Rbleed76 n76 0 160000
Rser77 n76 ns77 0.0134571259295
Lser77 ns77 n77 1.14623552124e-07
Cfixed77 n77 0 1.96006274131e-12
Dvar77a n77 vst77 DVAR
Dvar77b vst77 vb DVAR
Rstack77 vst77 vb 2000000
Rbleed77 n77 0 160000
Rser78 n77 ns78 0.0134571259295
Lser78 ns78 n78 1.14623552124e-07
Cfixed78 n78 0 1.96006274131e-12
Dvar78a n78 vst78 DVAR
Dvar78b vst78 vb DVAR
Rstack78 vst78 vb 2000000
Rbleed78 n78 0 160000
Rser79 n78 ns79 0.0134571259295
Lser79 ns79 n79 1.14623552124e-07
Cfixed79 n79 0 1.96006274131e-12
Dvar79a n79 vst79 DVAR
Dvar79b vst79 vb DVAR
Rstack79 vst79 vb 2000000
Rbleed79 n79 0 160000
Rser80 n79 ns80 0.0134571259295
Lser80 ns80 n80 1.14623552124e-07
Cfixed80 n80 0 1.96006274131e-12
Dvar80a n80 vst80 DVAR
Dvar80b vst80 vb DVAR
Rstack80 vst80 vb 2000000
Rbleed80 n80 0 160000
Rser81 n80 ns81 0.0134571259295
Lser81 ns81 n81 1.14623552124e-07
Cfixed81 n81 0 1.96006274131e-12
Dvar81a n81 vst81 DVAR
Dvar81b vst81 vb DVAR
Rstack81 vst81 vb 2000000
Rbleed81 n81 0 160000
Rser82 n81 ns82 0.0134571259295
Lser82 ns82 n82 1.14623552124e-07
Cfixed82 n82 0 1.96006274131e-12
Dvar82a n82 vst82 DVAR
Dvar82b vst82 vb DVAR
Rstack82 vst82 vb 2000000
Rbleed82 n82 0 160000
Rser83 n82 ns83 0.0134571259295
Lser83 ns83 n83 1.14623552124e-07
Cfixed83 n83 0 1.96006274131e-12
Dvar83a n83 vst83 DVAR
Dvar83b vst83 vb DVAR
Rstack83 vst83 vb 2000000
Rbleed83 n83 0 160000
Rser84 n83 ns84 0.0134571259295
Lser84 ns84 n84 1.14623552124e-07
Cfixed84 n84 0 1.96006274131e-12
Dvar84a n84 vst84 DVAR
Dvar84b vst84 vb DVAR
Rstack84 vst84 vb 2000000
Rbleed84 n84 0 160000
Rser85 n84 ns85 0.0134571259295
Lser85 ns85 n85 1.14623552124e-07
Cfixed85 n85 0 1.96006274131e-12
Dvar85a n85 vst85 DVAR
Dvar85b vst85 vb DVAR
Rstack85 vst85 vb 2000000
Rbleed85 n85 0 160000
Rser86 n85 ns86 0.0134571259295
Lser86 ns86 n86 1.14623552124e-07
Cfixed86 n86 0 1.96006274131e-12
Dvar86a n86 vst86 DVAR
Dvar86b vst86 vb DVAR
Rstack86 vst86 vb 2000000
Rbleed86 n86 0 160000
Rser87 n86 ns87 0.0134571259295
Lser87 ns87 n87 1.14623552124e-07
Cfixed87 n87 0 1.96006274131e-12
Dvar87a n87 vst87 DVAR
Dvar87b vst87 vb DVAR
Rstack87 vst87 vb 2000000
Rbleed87 n87 0 160000
Rser88 n87 ns88 0.0134571259295
Lser88 ns88 n88 1.14623552124e-07
Cfixed88 n88 0 1.96006274131e-12
Dvar88a n88 vst88 DVAR
Dvar88b vst88 vb DVAR
Rstack88 vst88 vb 2000000
Rbleed88 n88 0 160000
Rser89 n88 ns89 0.0134571259295
Lser89 ns89 n89 1.14623552124e-07
Cfixed89 n89 0 1.96006274131e-12
Dvar89a n89 vst89 DVAR
Dvar89b vst89 vb DVAR
Rstack89 vst89 vb 2000000
Rbleed89 n89 0 160000
Rser90 n89 ns90 0.0134571259295
Lser90 ns90 n90 1.14623552124e-07
Cfixed90 n90 0 1.96006274131e-12
Dvar90a n90 vst90 DVAR
Dvar90b vst90 vb DVAR
Rstack90 vst90 vb 2000000
Rbleed90 n90 0 160000
Rser91 n90 ns91 0.0134571259295
Lser91 ns91 n91 1.14623552124e-07
Cfixed91 n91 0 1.96006274131e-12
Dvar91a n91 vst91 DVAR
Dvar91b vst91 vb DVAR
Rstack91 vst91 vb 2000000
Rbleed91 n91 0 160000
Rser92 n91 ns92 0.0134571259295
Lser92 ns92 n92 1.14623552124e-07
Cfixed92 n92 0 1.96006274131e-12
Dvar92a n92 vst92 DVAR
Dvar92b vst92 vb DVAR
Rstack92 vst92 vb 2000000
Rbleed92 n92 0 160000
Rser93 n92 ns93 0.0134571259295
Lser93 ns93 n93 1.14623552124e-07
Cfixed93 n93 0 1.96006274131e-12
Dvar93a n93 vst93 DVAR
Dvar93b vst93 vb DVAR
Rstack93 vst93 vb 2000000
Rbleed93 n93 0 160000
Rser94 n93 ns94 0.0134571259295
Lser94 ns94 n94 1.14623552124e-07
Cfixed94 n94 0 1.96006274131e-12
Dvar94a n94 vst94 DVAR
Dvar94b vst94 vb DVAR
Rstack94 vst94 vb 2000000
Rbleed94 n94 0 160000
Rser95 n94 ns95 0.0134571259295
Lser95 ns95 n95 1.14623552124e-07
Cfixed95 n95 0 1.96006274131e-12
Dvar95a n95 vst95 DVAR
Dvar95b vst95 vb DVAR
Rstack95 vst95 vb 2000000
Rbleed95 n95 0 160000
Rser96 n95 ns96 0.0134571259295
Lser96 ns96 n96 1.14623552124e-07
Cfixed96 n96 0 1.96006274131e-12
Dvar96a n96 vst96 DVAR
Dvar96b vst96 vb DVAR
Rstack96 vst96 vb 2000000
Rbleed96 n96 0 160000
Rser97 n96 ns97 0.0134571259295
Lser97 ns97 n97 1.14623552124e-07
Cfixed97 n97 0 1.96006274131e-12
Dvar97a n97 vst97 DVAR
Dvar97b vst97 vb DVAR
Rstack97 vst97 vb 2000000
Rbleed97 n97 0 160000
Rser98 n97 ns98 0.0134571259295
Lser98 ns98 n98 1.14623552124e-07
Cfixed98 n98 0 1.96006274131e-12
Dvar98a n98 vst98 DVAR
Dvar98b vst98 vb DVAR
Rstack98 vst98 vb 2000000
Rbleed98 n98 0 160000
Rser99 n98 ns99 0.0134571259295
Lser99 ns99 n99 1.14623552124e-07
Cfixed99 n99 0 1.96006274131e-12
Dvar99a n99 vst99 DVAR
Dvar99b vst99 vb DVAR
Rstack99 vst99 vb 2000000
Rbleed99 n99 0 160000
Rser100 n99 ns100 0.0134571259295
Lser100 ns100 n100 1.14623552124e-07
Cfixed100 n100 0 1.96006274131e-12
Dvar100a n100 vst100 DVAR
Dvar100b vst100 vb DVAR
Rstack100 vst100 vb 2000000
Rbleed100 n100 0 160000
Rser101 n100 ns101 0.0134571259295
Lser101 ns101 n101 1.14623552124e-07
Cfixed101 n101 0 1.96006274131e-12
Dvar101a n101 vst101 DVAR
Dvar101b vst101 vb DVAR
Rstack101 vst101 vb 2000000
Rbleed101 n101 0 160000
Rser102 n101 ns102 0.0134571259295
Lser102 ns102 n102 1.14623552124e-07
Cfixed102 n102 0 1.96006274131e-12
Dvar102a n102 vst102 DVAR
Dvar102b vst102 vb DVAR
Rstack102 vst102 vb 2000000
Rbleed102 n102 0 160000
Rser103 n102 ns103 0.0134571259295
Lser103 ns103 n103 1.14623552124e-07
Cfixed103 n103 0 1.96006274131e-12
Dvar103a n103 vst103 DVAR
Dvar103b vst103 vb DVAR
Rstack103 vst103 vb 2000000
Rbleed103 n103 0 160000
Rser104 n103 ns104 0.0134571259295
Lser104 ns104 n104 1.14623552124e-07
Cfixed104 n104 0 1.96006274131e-12
Dvar104a n104 vst104 DVAR
Dvar104b vst104 vb DVAR
Rstack104 vst104 vb 2000000
Rbleed104 n104 0 160000
Rser105 n104 ns105 0.0134571259295
Lser105 ns105 n105 1.14623552124e-07
Cfixed105 n105 0 1.96006274131e-12
Dvar105a n105 vst105 DVAR
Dvar105b vst105 vb DVAR
Rstack105 vst105 vb 2000000
Rbleed105 n105 0 160000
Rser106 n105 ns106 0.0134571259295
Lser106 ns106 n106 1.14623552124e-07
Cfixed106 n106 0 1.96006274131e-12
Dvar106a n106 vst106 DVAR
Dvar106b vst106 vb DVAR
Rstack106 vst106 vb 2000000
Rbleed106 n106 0 160000
Rser107 n106 ns107 0.0134571259295
Lser107 ns107 n107 1.14623552124e-07
Cfixed107 n107 0 1.96006274131e-12
Dvar107a n107 vst107 DVAR
Dvar107b vst107 vb DVAR
Rstack107 vst107 vb 2000000
Rbleed107 n107 0 160000
Rser108 n107 ns108 0.0134571259295
Lser108 ns108 n108 1.14623552124e-07
Cfixed108 n108 0 1.96006274131e-12
Dvar108a n108 vst108 DVAR
Dvar108b vst108 vb DVAR
Rstack108 vst108 vb 2000000
Rbleed108 n108 0 160000
Rser109 n108 ns109 0.0134571259295
Lser109 ns109 n109 1.14623552124e-07
Cfixed109 n109 0 1.96006274131e-12
Dvar109a n109 vst109 DVAR
Dvar109b vst109 vb DVAR
Rstack109 vst109 vb 2000000
Rbleed109 n109 0 160000
Rser110 n109 ns110 0.0134571259295
Lser110 ns110 n110 1.14623552124e-07
Cfixed110 n110 0 1.96006274131e-12
Dvar110a n110 vst110 DVAR
Dvar110b vst110 vb DVAR
Rstack110 vst110 vb 2000000
Rbleed110 n110 0 160000
Rser111 n110 ns111 0.0134571259295
Lser111 ns111 n111 1.14623552124e-07
Cfixed111 n111 0 1.96006274131e-12
Dvar111a n111 vst111 DVAR
Dvar111b vst111 vb DVAR
Rstack111 vst111 vb 2000000
Rbleed111 n111 0 160000
Rser112 n111 ns112 0.0134571259295
Lser112 ns112 n112 1.14623552124e-07
Cfixed112 n112 0 1.96006274131e-12
Dvar112a n112 vst112 DVAR
Dvar112b vst112 vb DVAR
Rstack112 vst112 vb 2000000
Rbleed112 n112 0 160000
Rser113 n112 ns113 0.0134571259295
Lser113 ns113 n113 1.14623552124e-07
Cfixed113 n113 0 1.96006274131e-12
Dvar113a n113 vst113 DVAR
Dvar113b vst113 vb DVAR
Rstack113 vst113 vb 2000000
Rbleed113 n113 0 160000
Rser114 n113 ns114 0.0134571259295
Lser114 ns114 n114 1.14623552124e-07
Cfixed114 n114 0 1.96006274131e-12
Dvar114a n114 vst114 DVAR
Dvar114b vst114 vb DVAR
Rstack114 vst114 vb 2000000
Rbleed114 n114 0 160000
Rser115 n114 ns115 0.0134571259295
Lser115 ns115 n115 1.14623552124e-07
Cfixed115 n115 0 1.96006274131e-12
Dvar115a n115 vst115 DVAR
Dvar115b vst115 vb DVAR
Rstack115 vst115 vb 2000000
Rbleed115 n115 0 160000
Rser116 n115 ns116 0.0134571259295
Lser116 ns116 n116 1.14623552124e-07
Cfixed116 n116 0 1.96006274131e-12
Dvar116a n116 vst116 DVAR
Dvar116b vst116 vb DVAR
Rstack116 vst116 vb 2000000
Rbleed116 n116 0 160000
Rser117 n116 ns117 0.0134571259295
Lser117 ns117 n117 1.14623552124e-07
Cfixed117 n117 0 1.96006274131e-12
Dvar117a n117 vst117 DVAR
Dvar117b vst117 vb DVAR
Rstack117 vst117 vb 2000000
Rbleed117 n117 0 160000
Rser118 n117 ns118 0.0134571259295
Lser118 ns118 n118 1.14623552124e-07
Cfixed118 n118 0 1.96006274131e-12
Dvar118a n118 vst118 DVAR
Dvar118b vst118 vb DVAR
Rstack118 vst118 vb 2000000
Rbleed118 n118 0 160000
Rser119 n118 ns119 0.0134571259295
Lser119 ns119 n119 1.14623552124e-07
Cfixed119 n119 0 1.96006274131e-12
Dvar119a n119 vst119 DVAR
Dvar119b vst119 vb DVAR
Rstack119 vst119 vb 2000000
Rbleed119 n119 0 160000
Rser120 n119 ns120 0.0134571259295
Lser120 ns120 n120 1.14623552124e-07
Cfixed120 n120 0 1.96006274131e-12
Dvar120a n120 vst120 DVAR
Dvar120b vst120 vb DVAR
Rstack120 vst120 vb 2000000
Rbleed120 n120 0 160000
Rser121 n120 ns121 0.0134571259295
Lser121 ns121 n121 1.14623552124e-07
Cfixed121 n121 0 1.96006274131e-12
Dvar121a n121 vst121 DVAR
Dvar121b vst121 vb DVAR
Rstack121 vst121 vb 2000000
Rbleed121 n121 0 160000
Rser122 n121 ns122 0.0134571259295
Lser122 ns122 n122 1.14623552124e-07
Cfixed122 n122 0 1.96006274131e-12
Dvar122a n122 vst122 DVAR
Dvar122b vst122 vb DVAR
Rstack122 vst122 vb 2000000
Rbleed122 n122 0 160000
Rser123 n122 ns123 0.0134571259295
Lser123 ns123 n123 1.14623552124e-07
Cfixed123 n123 0 1.96006274131e-12
Dvar123a n123 vst123 DVAR
Dvar123b vst123 vb DVAR
Rstack123 vst123 vb 2000000
Rbleed123 n123 0 160000
Rser124 n123 ns124 0.0134571259295
Lser124 ns124 n124 1.14623552124e-07
Cfixed124 n124 0 1.96006274131e-12
Dvar124a n124 vst124 DVAR
Dvar124b vst124 vb DVAR
Rstack124 vst124 vb 2000000
Rbleed124 n124 0 160000
Rser125 n124 ns125 0.0134571259295
Lser125 ns125 n125 1.14623552124e-07
Cfixed125 n125 0 1.96006274131e-12
Dvar125a n125 vst125 DVAR
Dvar125b vst125 vb DVAR
Rstack125 vst125 vb 2000000
Rbleed125 n125 0 160000
Rser126 n125 ns126 0.0134571259295
Lser126 ns126 n126 1.14623552124e-07
Cfixed126 n126 0 1.96006274131e-12
Dvar126a n126 vst126 DVAR
Dvar126b vst126 vb DVAR
Rstack126 vst126 vb 2000000
Rbleed126 n126 0 160000
Rser127 n126 ns127 0.0134571259295
Lser127 ns127 n127 1.14623552124e-07
Cfixed127 n127 0 1.96006274131e-12
Dvar127a n127 vst127 DVAR
Dvar127b vst127 vb DVAR
Rstack127 vst127 vb 2000000
Rbleed127 n127 0 160000
Rser128 n127 ns128 0.0134571259295
Lser128 ns128 n128 1.14623552124e-07
Cfixed128 n128 0 1.96006274131e-12
Dvar128a n128 vst128 DVAR
Dvar128b vst128 vb DVAR
Rstack128 vst128 vb 2000000
Rbleed128 n128 0 160000
Bmag2 n2 0 I={(1.08081664341)*kmag*V(n2)*V(n2)*V(n2)/(1+(V(n2)/10)**2) + gcore*V(n2)}
Bmag18 n18 0 I={(1.10023844539)*kmag*V(n18)*V(n18)*V(n18)/(1+(V(n18)/10)**2) + gcore*V(n18)}
Bmag34 n34 0 I={(1.11809605994)*kmag*V(n34)*V(n34)*V(n34)/(1+(V(n34)/10)**2) + gcore*V(n34)}
Bmag50 n50 0 I={(1.13411082498)*kmag*V(n50)*V(n50)*V(n50)/(1+(V(n50)/10)**2) + gcore*V(n50)}
Bmag66 n66 0 I={(1.14803283545)*kmag*V(n66)*V(n66)*V(n66)/(1+(V(n66)/10)**2) + gcore*V(n66)}
Bmag82 n82 0 I={(1.15964484303)*kmag*V(n82)*V(n82)*V(n82)/(1+(V(n82)/10)**2) + gcore*V(n82)}
Bmag98 n98 0 I={(1.16876564623)*kmag*V(n98)*V(n98)*V(n98)/(1+(V(n98)/10)**2) + gcore*V(n98)}
Bmag114 n114 0 I={(1.17525291797)*kmag*V(n114)*V(n114)*V(n114)/(1+(V(n114)/10)**2) + gcore*V(n114)}
Rext n128 ext_r 6.69465180151
Lext ext_r ext_l 2.16123108821e-07
Cext ext_l v150 5.358e-12
Rload150 v150 0 240
Rpost150 v150 post_r 4.61603264076
Lpost150 post_r post_l 3.8202549437e-07
Cpost150 post_l v150f 2.9469e-12
Rload150f v150f 0 374.4
Rtrap50 n128 tr50_r 17.6838825658
Ltrap50 tr50_r tr50_l 1.12579092936e-06
Ctrap50 tr50_l 0 9e-12
Rtrap100 n128 tr100_r 12.2450239039
Ltrap100 tr100_r tr100_l 3.6807421043e-07
Ctrap100 tr100_l 0 6.8e-12
.control
set filetype=ascii
set wr_singlescale
set wr_vecnames
tran 5e-10 5.5e-07 0 2e-10
wrdata h019_alternating_varactor_magnetic_cells_128c_100ohm_tran.csv time v(n0) v(n64) v(v150f) i(Vsrc) i(Vbias)
.endc
.end

* h022_middle_third_only_128c_100ohm
* Hybrid varactor-plus-magnetic 50/100/150 MHz refinement track.
* role=discovery; source_only=True; no direct 100/150 MHz discovery drive.
* placement=middle_third_only; magnetic_curve=soft; cleanup=extraction_plus_rejection
.option method=gear maxord=2 reltol=2e-4 abstol=1e-12 vntol=1e-6 chgtol=1e-16 itl4=280
.model DVAR D(Is=1e-15 Rs=0.34 Cjo=4.29463277589e-11 Vj=0.65 M=0.58 Bv=18 Ibv=1e-06)
.param kmag=1.9475e-06
.param gcore=1.5e-07
Vbias vb 0 DC 3.4
Vsrc src 0 SIN(0 1.9 50000000)
Rsrc src n0 100
Rrawload n128 0 300
Cbase0 n0 0 1.25e-11
Rbleed0 n0 0 160000
Rser1 n0 ns1 0.0134571259295
Lser1 ns1 n1 1.25e-07
Cbase1 n1 0 1.25e-11
Rbleed1 n1 0 160000
Rser2 n1 ns2 0.0134571259295
Lser2 ns2 n2 1.25e-07
Cbase2 n2 0 1.25e-11
Rbleed2 n2 0 160000
Rser3 n2 ns3 0.0134571259295
Lser3 ns3 n3 1.25e-07
Cbase3 n3 0 1.25e-11
Rbleed3 n3 0 160000
Rser4 n3 ns4 0.0134571259295
Lser4 ns4 n4 1.25e-07
Cbase4 n4 0 1.25e-11
Rbleed4 n4 0 160000
Rser5 n4 ns5 0.0134571259295
Lser5 ns5 n5 1.25e-07
Cbase5 n5 0 1.25e-11
Rbleed5 n5 0 160000
Rser6 n5 ns6 0.0134571259295
Lser6 ns6 n6 1.25e-07
Cbase6 n6 0 1.25e-11
Rbleed6 n6 0 160000
Rser7 n6 ns7 0.0134571259295
Lser7 ns7 n7 1.25e-07
Cbase7 n7 0 1.25e-11
Rbleed7 n7 0 160000
Rser8 n7 ns8 0.0134571259295
Lser8 ns8 n8 1.25e-07
Cbase8 n8 0 1.25e-11
Rbleed8 n8 0 160000
Rser9 n8 ns9 0.0134571259295
Lser9 ns9 n9 1.25e-07
Cbase9 n9 0 1.25e-11
Rbleed9 n9 0 160000
Rser10 n9 ns10 0.0134571259295
Lser10 ns10 n10 1.25e-07
Cbase10 n10 0 1.25e-11
Rbleed10 n10 0 160000
Rser11 n10 ns11 0.0134571259295
Lser11 ns11 n11 1.25e-07
Cbase11 n11 0 1.25e-11
Rbleed11 n11 0 160000
Rser12 n11 ns12 0.0134571259295
Lser12 ns12 n12 1.25e-07
Cbase12 n12 0 1.25e-11
Rbleed12 n12 0 160000
Rser13 n12 ns13 0.0134571259295
Lser13 ns13 n13 1.25e-07
Cbase13 n13 0 1.25e-11
Rbleed13 n13 0 160000
Rser14 n13 ns14 0.0134571259295
Lser14 ns14 n14 1.25e-07
Cbase14 n14 0 1.25e-11
Rbleed14 n14 0 160000
Rser15 n14 ns15 0.0134571259295
Lser15 ns15 n15 1.25e-07
Cbase15 n15 0 1.25e-11
Rbleed15 n15 0 160000
Rser16 n15 ns16 0.0134571259295
Lser16 ns16 n16 1.25e-07
Cbase16 n16 0 1.25e-11
Rbleed16 n16 0 160000
Rser17 n16 ns17 0.0134571259295
Lser17 ns17 n17 1.25e-07
Cbase17 n17 0 1.25e-11
Rbleed17 n17 0 160000
Rser18 n17 ns18 0.0134571259295
Lser18 ns18 n18 1.25e-07
Cbase18 n18 0 1.25e-11
Rbleed18 n18 0 160000
Rser19 n18 ns19 0.0134571259295
Lser19 ns19 n19 1.25e-07
Cbase19 n19 0 1.25e-11
Rbleed19 n19 0 160000
Rser20 n19 ns20 0.0134571259295
Lser20 ns20 n20 1.25e-07
Cbase20 n20 0 1.25e-11
Rbleed20 n20 0 160000
Rser21 n20 ns21 0.0134571259295
Lser21 ns21 n21 1.25e-07
Cbase21 n21 0 1.25e-11
Rbleed21 n21 0 160000
Rser22 n21 ns22 0.0134571259295
Lser22 ns22 n22 1.25e-07
Cbase22 n22 0 1.25e-11
Rbleed22 n22 0 160000
Rser23 n22 ns23 0.0134571259295
Lser23 ns23 n23 1.25e-07
Cbase23 n23 0 1.25e-11
Rbleed23 n23 0 160000
Rser24 n23 ns24 0.0134571259295
Lser24 ns24 n24 1.25e-07
Cbase24 n24 0 1.25e-11
Rbleed24 n24 0 160000
Rser25 n24 ns25 0.0134571259295
Lser25 ns25 n25 1.25e-07
Cbase25 n25 0 1.25e-11
Rbleed25 n25 0 160000
Rser26 n25 ns26 0.0134571259295
Lser26 ns26 n26 1.25e-07
Cbase26 n26 0 1.25e-11
Rbleed26 n26 0 160000
Rser27 n26 ns27 0.0134571259295
Lser27 ns27 n27 1.25e-07
Cbase27 n27 0 1.25e-11
Rbleed27 n27 0 160000
Rser28 n27 ns28 0.0134571259295
Lser28 ns28 n28 1.25e-07
Cbase28 n28 0 1.25e-11
Rbleed28 n28 0 160000
Rser29 n28 ns29 0.0134571259295
Lser29 ns29 n29 1.25e-07
Cbase29 n29 0 1.25e-11
Rbleed29 n29 0 160000
Rser30 n29 ns30 0.0134571259295
Lser30 ns30 n30 1.25e-07
Cbase30 n30 0 1.25e-11
Rbleed30 n30 0 160000
Rser31 n30 ns31 0.0134571259295
Lser31 ns31 n31 1.25e-07
Cbase31 n31 0 1.25e-11
Rbleed31 n31 0 160000
Rser32 n31 ns32 0.0134571259295
Lser32 ns32 n32 1.25e-07
Cbase32 n32 0 1.25e-11
Rbleed32 n32 0 160000
Rser33 n32 ns33 0.0134571259295
Lser33 ns33 n33 1.25e-07
Cbase33 n33 0 1.25e-11
Rbleed33 n33 0 160000
Rser34 n33 ns34 0.0134571259295
Lser34 ns34 n34 1.25e-07
Cbase34 n34 0 1.25e-11
Rbleed34 n34 0 160000
Rser35 n34 ns35 0.0134571259295
Lser35 ns35 n35 1.25e-07
Cbase35 n35 0 1.25e-11
Rbleed35 n35 0 160000
Rser36 n35 ns36 0.0134571259295
Lser36 ns36 n36 1.25e-07
Cbase36 n36 0 1.25e-11
Rbleed36 n36 0 160000
Rser37 n36 ns37 0.0134571259295
Lser37 ns37 n37 1.25e-07
Cbase37 n37 0 1.25e-11
Rbleed37 n37 0 160000
Rser38 n37 ns38 0.0134571259295
Lser38 ns38 n38 1.25e-07
Cbase38 n38 0 1.25e-11
Rbleed38 n38 0 160000
Rser39 n38 ns39 0.0134571259295
Lser39 ns39 n39 1.25e-07
Cbase39 n39 0 1.25e-11
Rbleed39 n39 0 160000
Rser40 n39 ns40 0.0134571259295
Lser40 ns40 n40 1.25e-07
Cbase40 n40 0 1.25e-11
Rbleed40 n40 0 160000
Rser41 n40 ns41 0.0134571259295
Lser41 ns41 n41 1.25e-07
Cbase41 n41 0 1.25e-11
Rbleed41 n41 0 160000
Rser42 n41 ns42 0.0134571259295
Lser42 ns42 n42 1.25e-07
Cfixed42 n42 0 2.1375e-12
Dvar42a n42 vst42 DVAR
Dvar42b vst42 vb DVAR
Rstack42 vst42 vb 2000000
Rbleed42 n42 0 160000
Rser43 n42 ns43 0.0134571259295
Lser43 ns43 n43 1.25e-07
Cfixed43 n43 0 2.1375e-12
Dvar43a n43 vst43 DVAR
Dvar43b vst43 vb DVAR
Rstack43 vst43 vb 2000000
Rbleed43 n43 0 160000
Rser44 n43 ns44 0.0134571259295
Lser44 ns44 n44 1.25e-07
Cfixed44 n44 0 2.1375e-12
Dvar44a n44 vst44 DVAR
Dvar44b vst44 vb DVAR
Rstack44 vst44 vb 2000000
Rbleed44 n44 0 160000
Rser45 n44 ns45 0.0134571259295
Lser45 ns45 n45 1.25e-07
Cfixed45 n45 0 2.1375e-12
Dvar45a n45 vst45 DVAR
Dvar45b vst45 vb DVAR
Rstack45 vst45 vb 2000000
Rbleed45 n45 0 160000
Rser46 n45 ns46 0.0134571259295
Lser46 ns46 n46 1.25e-07
Cfixed46 n46 0 2.1375e-12
Dvar46a n46 vst46 DVAR
Dvar46b vst46 vb DVAR
Rstack46 vst46 vb 2000000
Rbleed46 n46 0 160000
Rser47 n46 ns47 0.0134571259295
Lser47 ns47 n47 1.25e-07
Cfixed47 n47 0 2.1375e-12
Dvar47a n47 vst47 DVAR
Dvar47b vst47 vb DVAR
Rstack47 vst47 vb 2000000
Rbleed47 n47 0 160000
Rser48 n47 ns48 0.0134571259295
Lser48 ns48 n48 1.25e-07
Cfixed48 n48 0 2.1375e-12
Dvar48a n48 vst48 DVAR
Dvar48b vst48 vb DVAR
Rstack48 vst48 vb 2000000
Rbleed48 n48 0 160000
Rser49 n48 ns49 0.0134571259295
Lser49 ns49 n49 1.25e-07
Cfixed49 n49 0 2.1375e-12
Dvar49a n49 vst49 DVAR
Dvar49b vst49 vb DVAR
Rstack49 vst49 vb 2000000
Rbleed49 n49 0 160000
Rser50 n49 ns50 0.0134571259295
Lser50 ns50 n50 1.25e-07
Cfixed50 n50 0 2.1375e-12
Dvar50a n50 vst50 DVAR
Dvar50b vst50 vb DVAR
Rstack50 vst50 vb 2000000
Rbleed50 n50 0 160000
Rser51 n50 ns51 0.0134571259295
Lser51 ns51 n51 1.25e-07
Cfixed51 n51 0 2.1375e-12
Dvar51a n51 vst51 DVAR
Dvar51b vst51 vb DVAR
Rstack51 vst51 vb 2000000
Rbleed51 n51 0 160000
Rser52 n51 ns52 0.0134571259295
Lser52 ns52 n52 1.25e-07
Cfixed52 n52 0 2.1375e-12
Dvar52a n52 vst52 DVAR
Dvar52b vst52 vb DVAR
Rstack52 vst52 vb 2000000
Rbleed52 n52 0 160000
Rser53 n52 ns53 0.0134571259295
Lser53 ns53 n53 1.25e-07
Cfixed53 n53 0 2.1375e-12
Dvar53a n53 vst53 DVAR
Dvar53b vst53 vb DVAR
Rstack53 vst53 vb 2000000
Rbleed53 n53 0 160000
Rser54 n53 ns54 0.0134571259295
Lser54 ns54 n54 1.25e-07
Cfixed54 n54 0 2.1375e-12
Dvar54a n54 vst54 DVAR
Dvar54b vst54 vb DVAR
Rstack54 vst54 vb 2000000
Rbleed54 n54 0 160000
Rser55 n54 ns55 0.0134571259295
Lser55 ns55 n55 1.25e-07
Cfixed55 n55 0 2.1375e-12
Dvar55a n55 vst55 DVAR
Dvar55b vst55 vb DVAR
Rstack55 vst55 vb 2000000
Rbleed55 n55 0 160000
Rser56 n55 ns56 0.0134571259295
Lser56 ns56 n56 1.25e-07
Cfixed56 n56 0 2.1375e-12
Dvar56a n56 vst56 DVAR
Dvar56b vst56 vb DVAR
Rstack56 vst56 vb 2000000
Rbleed56 n56 0 160000
Rser57 n56 ns57 0.0134571259295
Lser57 ns57 n57 1.25e-07
Cfixed57 n57 0 2.1375e-12
Dvar57a n57 vst57 DVAR
Dvar57b vst57 vb DVAR
Rstack57 vst57 vb 2000000
Rbleed57 n57 0 160000
Rser58 n57 ns58 0.0134571259295
Lser58 ns58 n58 1.25e-07
Cfixed58 n58 0 2.1375e-12
Dvar58a n58 vst58 DVAR
Dvar58b vst58 vb DVAR
Rstack58 vst58 vb 2000000
Rbleed58 n58 0 160000
Rser59 n58 ns59 0.0134571259295
Lser59 ns59 n59 1.25e-07
Cfixed59 n59 0 2.1375e-12
Dvar59a n59 vst59 DVAR
Dvar59b vst59 vb DVAR
Rstack59 vst59 vb 2000000
Rbleed59 n59 0 160000
Rser60 n59 ns60 0.0134571259295
Lser60 ns60 n60 1.25e-07
Cfixed60 n60 0 2.1375e-12
Dvar60a n60 vst60 DVAR
Dvar60b vst60 vb DVAR
Rstack60 vst60 vb 2000000
Rbleed60 n60 0 160000
Rser61 n60 ns61 0.0134571259295
Lser61 ns61 n61 1.25e-07
Cfixed61 n61 0 2.1375e-12
Dvar61a n61 vst61 DVAR
Dvar61b vst61 vb DVAR
Rstack61 vst61 vb 2000000
Rbleed61 n61 0 160000
Rser62 n61 ns62 0.0134571259295
Lser62 ns62 n62 1.25e-07
Cfixed62 n62 0 2.1375e-12
Dvar62a n62 vst62 DVAR
Dvar62b vst62 vb DVAR
Rstack62 vst62 vb 2000000
Rbleed62 n62 0 160000
Rser63 n62 ns63 0.0134571259295
Lser63 ns63 n63 1.25e-07
Cfixed63 n63 0 2.1375e-12
Dvar63a n63 vst63 DVAR
Dvar63b vst63 vb DVAR
Rstack63 vst63 vb 2000000
Rbleed63 n63 0 160000
Rser64 n63 ns64 0.0134571259295
Lser64 ns64 n64 1.25e-07
Cfixed64 n64 0 2.1375e-12
Dvar64a n64 vst64 DVAR
Dvar64b vst64 vb DVAR
Rstack64 vst64 vb 2000000
Rbleed64 n64 0 160000
Rser65 n64 ns65 0.0134571259295
Lser65 ns65 n65 1.25e-07
Cfixed65 n65 0 2.1375e-12
Dvar65a n65 vst65 DVAR
Dvar65b vst65 vb DVAR
Rstack65 vst65 vb 2000000
Rbleed65 n65 0 160000
Rser66 n65 ns66 0.0134571259295
Lser66 ns66 n66 1.25e-07
Cfixed66 n66 0 2.1375e-12
Dvar66a n66 vst66 DVAR
Dvar66b vst66 vb DVAR
Rstack66 vst66 vb 2000000
Rbleed66 n66 0 160000
Rser67 n66 ns67 0.0134571259295
Lser67 ns67 n67 1.25e-07
Cfixed67 n67 0 2.1375e-12
Dvar67a n67 vst67 DVAR
Dvar67b vst67 vb DVAR
Rstack67 vst67 vb 2000000
Rbleed67 n67 0 160000
Rser68 n67 ns68 0.0134571259295
Lser68 ns68 n68 1.25e-07
Cfixed68 n68 0 2.1375e-12
Dvar68a n68 vst68 DVAR
Dvar68b vst68 vb DVAR
Rstack68 vst68 vb 2000000
Rbleed68 n68 0 160000
Rser69 n68 ns69 0.0134571259295
Lser69 ns69 n69 1.25e-07
Cfixed69 n69 0 2.1375e-12
Dvar69a n69 vst69 DVAR
Dvar69b vst69 vb DVAR
Rstack69 vst69 vb 2000000
Rbleed69 n69 0 160000
Rser70 n69 ns70 0.0134571259295
Lser70 ns70 n70 1.25e-07
Cfixed70 n70 0 2.1375e-12
Dvar70a n70 vst70 DVAR
Dvar70b vst70 vb DVAR
Rstack70 vst70 vb 2000000
Rbleed70 n70 0 160000
Rser71 n70 ns71 0.0134571259295
Lser71 ns71 n71 1.25e-07
Cfixed71 n71 0 2.1375e-12
Dvar71a n71 vst71 DVAR
Dvar71b vst71 vb DVAR
Rstack71 vst71 vb 2000000
Rbleed71 n71 0 160000
Rser72 n71 ns72 0.0134571259295
Lser72 ns72 n72 1.25e-07
Cfixed72 n72 0 2.1375e-12
Dvar72a n72 vst72 DVAR
Dvar72b vst72 vb DVAR
Rstack72 vst72 vb 2000000
Rbleed72 n72 0 160000
Rser73 n72 ns73 0.0134571259295
Lser73 ns73 n73 1.25e-07
Cfixed73 n73 0 2.1375e-12
Dvar73a n73 vst73 DVAR
Dvar73b vst73 vb DVAR
Rstack73 vst73 vb 2000000
Rbleed73 n73 0 160000
Rser74 n73 ns74 0.0134571259295
Lser74 ns74 n74 1.25e-07
Cfixed74 n74 0 2.1375e-12
Dvar74a n74 vst74 DVAR
Dvar74b vst74 vb DVAR
Rstack74 vst74 vb 2000000
Rbleed74 n74 0 160000
Rser75 n74 ns75 0.0134571259295
Lser75 ns75 n75 1.25e-07
Cfixed75 n75 0 2.1375e-12
Dvar75a n75 vst75 DVAR
Dvar75b vst75 vb DVAR
Rstack75 vst75 vb 2000000
Rbleed75 n75 0 160000
Rser76 n75 ns76 0.0134571259295
Lser76 ns76 n76 1.25e-07
Cfixed76 n76 0 2.1375e-12
Dvar76a n76 vst76 DVAR
Dvar76b vst76 vb DVAR
Rstack76 vst76 vb 2000000
Rbleed76 n76 0 160000
Rser77 n76 ns77 0.0134571259295
Lser77 ns77 n77 1.25e-07
Cfixed77 n77 0 2.1375e-12
Dvar77a n77 vst77 DVAR
Dvar77b vst77 vb DVAR
Rstack77 vst77 vb 2000000
Rbleed77 n77 0 160000
Rser78 n77 ns78 0.0134571259295
Lser78 ns78 n78 1.25e-07
Cfixed78 n78 0 2.1375e-12
Dvar78a n78 vst78 DVAR
Dvar78b vst78 vb DVAR
Rstack78 vst78 vb 2000000
Rbleed78 n78 0 160000
Rser79 n78 ns79 0.0134571259295
Lser79 ns79 n79 1.25e-07
Cfixed79 n79 0 2.1375e-12
Dvar79a n79 vst79 DVAR
Dvar79b vst79 vb DVAR
Rstack79 vst79 vb 2000000
Rbleed79 n79 0 160000
Rser80 n79 ns80 0.0134571259295
Lser80 ns80 n80 1.25e-07
Cfixed80 n80 0 2.1375e-12
Dvar80a n80 vst80 DVAR
Dvar80b vst80 vb DVAR
Rstack80 vst80 vb 2000000
Rbleed80 n80 0 160000
Rser81 n80 ns81 0.0134571259295
Lser81 ns81 n81 1.25e-07
Cfixed81 n81 0 2.1375e-12
Dvar81a n81 vst81 DVAR
Dvar81b vst81 vb DVAR
Rstack81 vst81 vb 2000000
Rbleed81 n81 0 160000
Rser82 n81 ns82 0.0134571259295
Lser82 ns82 n82 1.25e-07
Cfixed82 n82 0 2.1375e-12
Dvar82a n82 vst82 DVAR
Dvar82b vst82 vb DVAR
Rstack82 vst82 vb 2000000
Rbleed82 n82 0 160000
Rser83 n82 ns83 0.0134571259295
Lser83 ns83 n83 1.25e-07
Cfixed83 n83 0 2.1375e-12
Dvar83a n83 vst83 DVAR
Dvar83b vst83 vb DVAR
Rstack83 vst83 vb 2000000
Rbleed83 n83 0 160000
Rser84 n83 ns84 0.0134571259295
Lser84 ns84 n84 1.25e-07
Cfixed84 n84 0 2.1375e-12
Dvar84a n84 vst84 DVAR
Dvar84b vst84 vb DVAR
Rstack84 vst84 vb 2000000
Rbleed84 n84 0 160000
Rser85 n84 ns85 0.0134571259295
Lser85 ns85 n85 1.25e-07
Cfixed85 n85 0 2.1375e-12
Dvar85a n85 vst85 DVAR
Dvar85b vst85 vb DVAR
Rstack85 vst85 vb 2000000
Rbleed85 n85 0 160000
Rser86 n85 ns86 0.0134571259295
Lser86 ns86 n86 1.25e-07
Cbase86 n86 0 1.25e-11
Rbleed86 n86 0 160000
Rser87 n86 ns87 0.0134571259295
Lser87 ns87 n87 1.25e-07
Cbase87 n87 0 1.25e-11
Rbleed87 n87 0 160000
Rser88 n87 ns88 0.0134571259295
Lser88 ns88 n88 1.25e-07
Cbase88 n88 0 1.25e-11
Rbleed88 n88 0 160000
Rser89 n88 ns89 0.0134571259295
Lser89 ns89 n89 1.25e-07
Cbase89 n89 0 1.25e-11
Rbleed89 n89 0 160000
Rser90 n89 ns90 0.0134571259295
Lser90 ns90 n90 1.25e-07
Cbase90 n90 0 1.25e-11
Rbleed90 n90 0 160000
Rser91 n90 ns91 0.0134571259295
Lser91 ns91 n91 1.25e-07
Cbase91 n91 0 1.25e-11
Rbleed91 n91 0 160000
Rser92 n91 ns92 0.0134571259295
Lser92 ns92 n92 1.25e-07
Cbase92 n92 0 1.25e-11
Rbleed92 n92 0 160000
Rser93 n92 ns93 0.0134571259295
Lser93 ns93 n93 1.25e-07
Cbase93 n93 0 1.25e-11
Rbleed93 n93 0 160000
Rser94 n93 ns94 0.0134571259295
Lser94 ns94 n94 1.25e-07
Cbase94 n94 0 1.25e-11
Rbleed94 n94 0 160000
Rser95 n94 ns95 0.0134571259295
Lser95 ns95 n95 1.25e-07
Cbase95 n95 0 1.25e-11
Rbleed95 n95 0 160000
Rser96 n95 ns96 0.0134571259295
Lser96 ns96 n96 1.25e-07
Cbase96 n96 0 1.25e-11
Rbleed96 n96 0 160000
Rser97 n96 ns97 0.0134571259295
Lser97 ns97 n97 1.25e-07
Cbase97 n97 0 1.25e-11
Rbleed97 n97 0 160000
Rser98 n97 ns98 0.0134571259295
Lser98 ns98 n98 1.25e-07
Cbase98 n98 0 1.25e-11
Rbleed98 n98 0 160000
Rser99 n98 ns99 0.0134571259295
Lser99 ns99 n99 1.25e-07
Cbase99 n99 0 1.25e-11
Rbleed99 n99 0 160000
Rser100 n99 ns100 0.0134571259295
Lser100 ns100 n100 1.25e-07
Cbase100 n100 0 1.25e-11
Rbleed100 n100 0 160000
Rser101 n100 ns101 0.0134571259295
Lser101 ns101 n101 1.25e-07
Cbase101 n101 0 1.25e-11
Rbleed101 n101 0 160000
Rser102 n101 ns102 0.0134571259295
Lser102 ns102 n102 1.25e-07
Cbase102 n102 0 1.25e-11
Rbleed102 n102 0 160000
Rser103 n102 ns103 0.0134571259295
Lser103 ns103 n103 1.25e-07
Cbase103 n103 0 1.25e-11
Rbleed103 n103 0 160000
Rser104 n103 ns104 0.0134571259295
Lser104 ns104 n104 1.25e-07
Cbase104 n104 0 1.25e-11
Rbleed104 n104 0 160000
Rser105 n104 ns105 0.0134571259295
Lser105 ns105 n105 1.25e-07
Cbase105 n105 0 1.25e-11
Rbleed105 n105 0 160000
Rser106 n105 ns106 0.0134571259295
Lser106 ns106 n106 1.25e-07
Cbase106 n106 0 1.25e-11
Rbleed106 n106 0 160000
Rser107 n106 ns107 0.0134571259295
Lser107 ns107 n107 1.25e-07
Cbase107 n107 0 1.25e-11
Rbleed107 n107 0 160000
Rser108 n107 ns108 0.0134571259295
Lser108 ns108 n108 1.25e-07
Cbase108 n108 0 1.25e-11
Rbleed108 n108 0 160000
Rser109 n108 ns109 0.0134571259295
Lser109 ns109 n109 1.25e-07
Cbase109 n109 0 1.25e-11
Rbleed109 n109 0 160000
Rser110 n109 ns110 0.0134571259295
Lser110 ns110 n110 1.25e-07
Cbase110 n110 0 1.25e-11
Rbleed110 n110 0 160000
Rser111 n110 ns111 0.0134571259295
Lser111 ns111 n111 1.25e-07
Cbase111 n111 0 1.25e-11
Rbleed111 n111 0 160000
Rser112 n111 ns112 0.0134571259295
Lser112 ns112 n112 1.25e-07
Cbase112 n112 0 1.25e-11
Rbleed112 n112 0 160000
Rser113 n112 ns113 0.0134571259295
Lser113 ns113 n113 1.25e-07
Cbase113 n113 0 1.25e-11
Rbleed113 n113 0 160000
Rser114 n113 ns114 0.0134571259295
Lser114 ns114 n114 1.25e-07
Cbase114 n114 0 1.25e-11
Rbleed114 n114 0 160000
Rser115 n114 ns115 0.0134571259295
Lser115 ns115 n115 1.25e-07
Cbase115 n115 0 1.25e-11
Rbleed115 n115 0 160000
Rser116 n115 ns116 0.0134571259295
Lser116 ns116 n116 1.25e-07
Cbase116 n116 0 1.25e-11
Rbleed116 n116 0 160000
Rser117 n116 ns117 0.0134571259295
Lser117 ns117 n117 1.25e-07
Cbase117 n117 0 1.25e-11
Rbleed117 n117 0 160000
Rser118 n117 ns118 0.0134571259295
Lser118 ns118 n118 1.25e-07
Cbase118 n118 0 1.25e-11
Rbleed118 n118 0 160000
Rser119 n118 ns119 0.0134571259295
Lser119 ns119 n119 1.25e-07
Cbase119 n119 0 1.25e-11
Rbleed119 n119 0 160000
Rser120 n119 ns120 0.0134571259295
Lser120 ns120 n120 1.25e-07
Cbase120 n120 0 1.25e-11
Rbleed120 n120 0 160000
Rser121 n120 ns121 0.0134571259295
Lser121 ns121 n121 1.25e-07
Cbase121 n121 0 1.25e-11
Rbleed121 n121 0 160000
Rser122 n121 ns122 0.0134571259295
Lser122 ns122 n122 1.25e-07
Cbase122 n122 0 1.25e-11
Rbleed122 n122 0 160000
Rser123 n122 ns123 0.0134571259295
Lser123 ns123 n123 1.25e-07
Cbase123 n123 0 1.25e-11
Rbleed123 n123 0 160000
Rser124 n123 ns124 0.0134571259295
Lser124 ns124 n124 1.25e-07
Cbase124 n124 0 1.25e-11
Rbleed124 n124 0 160000
Rser125 n124 ns125 0.0134571259295
Lser125 ns125 n125 1.25e-07
Cbase125 n125 0 1.25e-11
Rbleed125 n125 0 160000
Rser126 n125 ns126 0.0134571259295
Lser126 ns126 n126 1.25e-07
Cbase126 n126 0 1.25e-11
Rbleed126 n126 0 160000
Rser127 n126 ns127 0.0134571259295
Lser127 ns127 n127 1.25e-07
Cbase127 n127 0 1.25e-11
Rbleed127 n127 0 160000
Rser128 n127 ns128 0.0134571259295
Lser128 ns128 n128 1.25e-07
Cbase128 n128 0 1.25e-11
Rbleed128 n128 0 160000
Bmag42 n42 0 I={(1.12635013976)*kmag*V(n42)*V(n42)*V(n42)/(1+(V(n42)/10)**2) + gcore*V(n42)}
Bmag46 n46 0 I={(1.13029409735)*kmag*V(n46)*V(n46)*V(n46)/(1+(V(n46)/10)**2) + gcore*V(n46)}
Bmag50 n50 0 I={(1.13411082498)*kmag*V(n50)*V(n50)*V(n50)/(1+(V(n50)/10)**2) + gcore*V(n50)}
Bmag54 n54 0 I={(1.13779659566)*kmag*V(n54)*V(n54)*V(n54)/(1+(V(n54)/10)**2) + gcore*V(n54)}
Bmag58 n58 0 I={(1.1413478103)*kmag*V(n58)*V(n58)*V(n58)/(1+(V(n58)/10)**2) + gcore*V(n58)}
Bmag62 n62 0 I={(1.1447610012)*kmag*V(n62)*V(n62)*V(n62)/(1+(V(n62)/10)**2) + gcore*V(n62)}
Bmag66 n66 0 I={(1.14803283545)*kmag*V(n66)*V(n66)*V(n66)/(1+(V(n66)/10)**2) + gcore*V(n66)}
Bmag70 n70 0 I={(1.15116011814)*kmag*V(n70)*V(n70)*V(n70)/(1+(V(n70)/10)**2) + gcore*V(n70)}
Bmag74 n74 0 I={(1.15413979554)*kmag*V(n74)*V(n74)*V(n74)/(1+(V(n74)/10)**2) + gcore*V(n74)}
Bmag78 n78 0 I={(1.15696895805)*kmag*V(n78)*V(n78)*V(n78)/(1+(V(n78)/10)**2) + gcore*V(n78)}
Bmag82 n82 0 I={(1.15964484303)*kmag*V(n82)*V(n82)*V(n82)/(1+(V(n82)/10)**2) + gcore*V(n82)}
Rext n128 ext_r 7.97314728858
Lext ext_r ext_l 2.22175830824e-07
Cext ext_l v150 5.17e-12
Rload150 v150 0 200
Rpost150 v150 post_r 6.5234841452
Lpost150 post_r post_l 3.95917330529e-07
Cpost150 post_l v150f 2.8435e-12
Rload150f v150f 0 280
Rtrap50 n128 tr50_r 17.6838825658
Ltrap50 tr50_r tr50_l 1.12579092936e-06
Ctrap50 tr50_l 0 9e-12
Rtrap100 n128 tr100_r 12.3184940474
Ltrap100 tr100_r tr100_l 3.72504351626e-07
Ctrap100 tr100_l 0 6.8e-12
.control
set filetype=ascii
set wr_singlescale
set wr_vecnames
tran 5e-10 5.5e-07 0 2e-10
wrdata h022_middle_third_only_128c_100ohm_tran.csv time v(n0) v(n64) v(v150f) i(Vsrc) i(Vbias)
.endc
.end

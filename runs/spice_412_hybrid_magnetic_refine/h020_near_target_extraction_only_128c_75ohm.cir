* h020_near_target_extraction_only_128c_75ohm
* Hybrid varactor-plus-magnetic 50/100/150 MHz refinement track.
* role=discovery; source_only=True; no direct 100/150 MHz discovery drive.
* placement=near_target_extraction_only; magnetic_curve=soft; cleanup=extraction_plus_rejection
.option method=gear maxord=2 reltol=2e-4 abstol=1e-12 vntol=1e-6 chgtol=1e-16 itl4=280
.model DVAR D(Is=1e-15 Rs=0.34 Cjo=4.53157803249e-11 Vj=0.65 M=0.58 Bv=18 Ibv=1e-06)
.param kmag=1.9475e-06
.param gcore=1.5e-07
Vbias vb 0 DC 3.4
Vsrc src 0 SIN(0 2.5 50000000)
Rsrc src n0 75
Rrawload n128 0 225
Cbase0 n0 0 1.41666666667e-11
Rbleed0 n0 0 160000
Rser1 n0 ns1 0.0116542129168
Lser1 ns1 n1 7.96875e-08
Cbase1 n1 0 1.41666666667e-11
Rbleed1 n1 0 160000
Rser2 n1 ns2 0.0116542129168
Lser2 ns2 n2 7.96875e-08
Cbase2 n2 0 1.41666666667e-11
Rbleed2 n2 0 160000
Rser3 n2 ns3 0.0116542129168
Lser3 ns3 n3 7.96875e-08
Cbase3 n3 0 1.41666666667e-11
Rbleed3 n3 0 160000
Rser4 n3 ns4 0.0116542129168
Lser4 ns4 n4 7.96875e-08
Cbase4 n4 0 1.41666666667e-11
Rbleed4 n4 0 160000
Rser5 n4 ns5 0.0116542129168
Lser5 ns5 n5 7.96875e-08
Cbase5 n5 0 1.41666666667e-11
Rbleed5 n5 0 160000
Rser6 n5 ns6 0.0116542129168
Lser6 ns6 n6 7.96875e-08
Cbase6 n6 0 1.41666666667e-11
Rbleed6 n6 0 160000
Rser7 n6 ns7 0.0116542129168
Lser7 ns7 n7 7.96875e-08
Cbase7 n7 0 1.41666666667e-11
Rbleed7 n7 0 160000
Rser8 n7 ns8 0.0116542129168
Lser8 ns8 n8 7.96875e-08
Cbase8 n8 0 1.41666666667e-11
Rbleed8 n8 0 160000
Rser9 n8 ns9 0.0116542129168
Lser9 ns9 n9 7.96875e-08
Cbase9 n9 0 1.41666666667e-11
Rbleed9 n9 0 160000
Rser10 n9 ns10 0.0116542129168
Lser10 ns10 n10 7.96875e-08
Cbase10 n10 0 1.41666666667e-11
Rbleed10 n10 0 160000
Rser11 n10 ns11 0.0116542129168
Lser11 ns11 n11 7.96875e-08
Cbase11 n11 0 1.41666666667e-11
Rbleed11 n11 0 160000
Rser12 n11 ns12 0.0116542129168
Lser12 ns12 n12 7.96875e-08
Cbase12 n12 0 1.41666666667e-11
Rbleed12 n12 0 160000
Rser13 n12 ns13 0.0116542129168
Lser13 ns13 n13 7.96875e-08
Cbase13 n13 0 1.41666666667e-11
Rbleed13 n13 0 160000
Rser14 n13 ns14 0.0116542129168
Lser14 ns14 n14 7.96875e-08
Cbase14 n14 0 1.41666666667e-11
Rbleed14 n14 0 160000
Rser15 n14 ns15 0.0116542129168
Lser15 ns15 n15 7.96875e-08
Cbase15 n15 0 1.41666666667e-11
Rbleed15 n15 0 160000
Rser16 n15 ns16 0.0116542129168
Lser16 ns16 n16 7.96875e-08
Cbase16 n16 0 1.41666666667e-11
Rbleed16 n16 0 160000
Rser17 n16 ns17 0.0116542129168
Lser17 ns17 n17 7.96875e-08
Cbase17 n17 0 1.41666666667e-11
Rbleed17 n17 0 160000
Rser18 n17 ns18 0.0116542129168
Lser18 ns18 n18 7.96875e-08
Cbase18 n18 0 1.41666666667e-11
Rbleed18 n18 0 160000
Rser19 n18 ns19 0.0116542129168
Lser19 ns19 n19 7.96875e-08
Cbase19 n19 0 1.41666666667e-11
Rbleed19 n19 0 160000
Rser20 n19 ns20 0.0116542129168
Lser20 ns20 n20 7.96875e-08
Cbase20 n20 0 1.41666666667e-11
Rbleed20 n20 0 160000
Rser21 n20 ns21 0.0116542129168
Lser21 ns21 n21 7.96875e-08
Cbase21 n21 0 1.41666666667e-11
Rbleed21 n21 0 160000
Rser22 n21 ns22 0.0116542129168
Lser22 ns22 n22 7.96875e-08
Cbase22 n22 0 1.41666666667e-11
Rbleed22 n22 0 160000
Rser23 n22 ns23 0.0116542129168
Lser23 ns23 n23 7.96875e-08
Cbase23 n23 0 1.41666666667e-11
Rbleed23 n23 0 160000
Rser24 n23 ns24 0.0116542129168
Lser24 ns24 n24 7.96875e-08
Cbase24 n24 0 1.41666666667e-11
Rbleed24 n24 0 160000
Rser25 n24 ns25 0.0116542129168
Lser25 ns25 n25 7.96875e-08
Cbase25 n25 0 1.41666666667e-11
Rbleed25 n25 0 160000
Rser26 n25 ns26 0.0116542129168
Lser26 ns26 n26 7.96875e-08
Cbase26 n26 0 1.41666666667e-11
Rbleed26 n26 0 160000
Rser27 n26 ns27 0.0116542129168
Lser27 ns27 n27 7.96875e-08
Cbase27 n27 0 1.41666666667e-11
Rbleed27 n27 0 160000
Rser28 n27 ns28 0.0116542129168
Lser28 ns28 n28 7.96875e-08
Cbase28 n28 0 1.41666666667e-11
Rbleed28 n28 0 160000
Rser29 n28 ns29 0.0116542129168
Lser29 ns29 n29 7.96875e-08
Cbase29 n29 0 1.41666666667e-11
Rbleed29 n29 0 160000
Rser30 n29 ns30 0.0116542129168
Lser30 ns30 n30 7.96875e-08
Cbase30 n30 0 1.41666666667e-11
Rbleed30 n30 0 160000
Rser31 n30 ns31 0.0116542129168
Lser31 ns31 n31 7.96875e-08
Cbase31 n31 0 1.41666666667e-11
Rbleed31 n31 0 160000
Rser32 n31 ns32 0.0116542129168
Lser32 ns32 n32 7.96875e-08
Cbase32 n32 0 1.41666666667e-11
Rbleed32 n32 0 160000
Rser33 n32 ns33 0.0116542129168
Lser33 ns33 n33 7.96875e-08
Cbase33 n33 0 1.41666666667e-11
Rbleed33 n33 0 160000
Rser34 n33 ns34 0.0116542129168
Lser34 ns34 n34 7.96875e-08
Cbase34 n34 0 1.41666666667e-11
Rbleed34 n34 0 160000
Rser35 n34 ns35 0.0116542129168
Lser35 ns35 n35 7.96875e-08
Cbase35 n35 0 1.41666666667e-11
Rbleed35 n35 0 160000
Rser36 n35 ns36 0.0116542129168
Lser36 ns36 n36 7.96875e-08
Cbase36 n36 0 1.41666666667e-11
Rbleed36 n36 0 160000
Rser37 n36 ns37 0.0116542129168
Lser37 ns37 n37 7.96875e-08
Cbase37 n37 0 1.41666666667e-11
Rbleed37 n37 0 160000
Rser38 n37 ns38 0.0116542129168
Lser38 ns38 n38 7.96875e-08
Cbase38 n38 0 1.41666666667e-11
Rbleed38 n38 0 160000
Rser39 n38 ns39 0.0116542129168
Lser39 ns39 n39 7.96875e-08
Cbase39 n39 0 1.41666666667e-11
Rbleed39 n39 0 160000
Rser40 n39 ns40 0.0116542129168
Lser40 ns40 n40 7.96875e-08
Cbase40 n40 0 1.41666666667e-11
Rbleed40 n40 0 160000
Rser41 n40 ns41 0.0116542129168
Lser41 ns41 n41 7.96875e-08
Cbase41 n41 0 1.41666666667e-11
Rbleed41 n41 0 160000
Rser42 n41 ns42 0.0116542129168
Lser42 ns42 n42 7.96875e-08
Cbase42 n42 0 1.41666666667e-11
Rbleed42 n42 0 160000
Rser43 n42 ns43 0.0116542129168
Lser43 ns43 n43 7.96875e-08
Cbase43 n43 0 1.41666666667e-11
Rbleed43 n43 0 160000
Rser44 n43 ns44 0.0116542129168
Lser44 ns44 n44 7.96875e-08
Cbase44 n44 0 1.41666666667e-11
Rbleed44 n44 0 160000
Rser45 n44 ns45 0.0116542129168
Lser45 ns45 n45 7.96875e-08
Cbase45 n45 0 1.41666666667e-11
Rbleed45 n45 0 160000
Rser46 n45 ns46 0.0116542129168
Lser46 ns46 n46 7.96875e-08
Cbase46 n46 0 1.41666666667e-11
Rbleed46 n46 0 160000
Rser47 n46 ns47 0.0116542129168
Lser47 ns47 n47 7.96875e-08
Cbase47 n47 0 1.41666666667e-11
Rbleed47 n47 0 160000
Rser48 n47 ns48 0.0116542129168
Lser48 ns48 n48 7.96875e-08
Cbase48 n48 0 1.41666666667e-11
Rbleed48 n48 0 160000
Rser49 n48 ns49 0.0116542129168
Lser49 ns49 n49 7.96875e-08
Cbase49 n49 0 1.41666666667e-11
Rbleed49 n49 0 160000
Rser50 n49 ns50 0.0116542129168
Lser50 ns50 n50 7.96875e-08
Cbase50 n50 0 1.41666666667e-11
Rbleed50 n50 0 160000
Rser51 n50 ns51 0.0116542129168
Lser51 ns51 n51 7.96875e-08
Cbase51 n51 0 1.41666666667e-11
Rbleed51 n51 0 160000
Rser52 n51 ns52 0.0116542129168
Lser52 ns52 n52 7.96875e-08
Cbase52 n52 0 1.41666666667e-11
Rbleed52 n52 0 160000
Rser53 n52 ns53 0.0116542129168
Lser53 ns53 n53 7.96875e-08
Cbase53 n53 0 1.41666666667e-11
Rbleed53 n53 0 160000
Rser54 n53 ns54 0.0116542129168
Lser54 ns54 n54 7.96875e-08
Cbase54 n54 0 1.41666666667e-11
Rbleed54 n54 0 160000
Rser55 n54 ns55 0.0116542129168
Lser55 ns55 n55 7.96875e-08
Cbase55 n55 0 1.41666666667e-11
Rbleed55 n55 0 160000
Rser56 n55 ns56 0.0116542129168
Lser56 ns56 n56 7.96875e-08
Cbase56 n56 0 1.41666666667e-11
Rbleed56 n56 0 160000
Rser57 n56 ns57 0.0116542129168
Lser57 ns57 n57 7.96875e-08
Cbase57 n57 0 1.41666666667e-11
Rbleed57 n57 0 160000
Rser58 n57 ns58 0.0116542129168
Lser58 ns58 n58 7.96875e-08
Cbase58 n58 0 1.41666666667e-11
Rbleed58 n58 0 160000
Rser59 n58 ns59 0.0116542129168
Lser59 ns59 n59 7.96875e-08
Cbase59 n59 0 1.41666666667e-11
Rbleed59 n59 0 160000
Rser60 n59 ns60 0.0116542129168
Lser60 ns60 n60 7.96875e-08
Cbase60 n60 0 1.41666666667e-11
Rbleed60 n60 0 160000
Rser61 n60 ns61 0.0116542129168
Lser61 ns61 n61 7.96875e-08
Cbase61 n61 0 1.41666666667e-11
Rbleed61 n61 0 160000
Rser62 n61 ns62 0.0116542129168
Lser62 ns62 n62 7.96875e-08
Cbase62 n62 0 1.41666666667e-11
Rbleed62 n62 0 160000
Rser63 n62 ns63 0.0116542129168
Lser63 ns63 n63 7.96875e-08
Cbase63 n63 0 1.41666666667e-11
Rbleed63 n63 0 160000
Rser64 n63 ns64 0.0116542129168
Lser64 ns64 n64 7.96875e-08
Cbase64 n64 0 1.41666666667e-11
Rbleed64 n64 0 160000
Rser65 n64 ns65 0.0116542129168
Lser65 ns65 n65 7.96875e-08
Cbase65 n65 0 1.41666666667e-11
Rbleed65 n65 0 160000
Rser66 n65 ns66 0.0116542129168
Lser66 ns66 n66 7.96875e-08
Cbase66 n66 0 1.41666666667e-11
Rbleed66 n66 0 160000
Rser67 n66 ns67 0.0116542129168
Lser67 ns67 n67 7.96875e-08
Cbase67 n67 0 1.41666666667e-11
Rbleed67 n67 0 160000
Rser68 n67 ns68 0.0116542129168
Lser68 ns68 n68 7.96875e-08
Cbase68 n68 0 1.41666666667e-11
Rbleed68 n68 0 160000
Rser69 n68 ns69 0.0116542129168
Lser69 ns69 n69 7.96875e-08
Cbase69 n69 0 1.41666666667e-11
Rbleed69 n69 0 160000
Rser70 n69 ns70 0.0116542129168
Lser70 ns70 n70 7.96875e-08
Cbase70 n70 0 1.41666666667e-11
Rbleed70 n70 0 160000
Rser71 n70 ns71 0.0116542129168
Lser71 ns71 n71 7.96875e-08
Cbase71 n71 0 1.41666666667e-11
Rbleed71 n71 0 160000
Rser72 n71 ns72 0.0116542129168
Lser72 ns72 n72 7.96875e-08
Cbase72 n72 0 1.41666666667e-11
Rbleed72 n72 0 160000
Rser73 n72 ns73 0.0116542129168
Lser73 ns73 n73 7.96875e-08
Cbase73 n73 0 1.41666666667e-11
Rbleed73 n73 0 160000
Rser74 n73 ns74 0.0116542129168
Lser74 ns74 n74 7.96875e-08
Cbase74 n74 0 1.41666666667e-11
Rbleed74 n74 0 160000
Rser75 n74 ns75 0.0116542129168
Lser75 ns75 n75 7.96875e-08
Cbase75 n75 0 1.41666666667e-11
Rbleed75 n75 0 160000
Rser76 n75 ns76 0.0116542129168
Lser76 ns76 n76 7.96875e-08
Cbase76 n76 0 1.41666666667e-11
Rbleed76 n76 0 160000
Rser77 n76 ns77 0.0116542129168
Lser77 ns77 n77 7.96875e-08
Cbase77 n77 0 1.41666666667e-11
Rbleed77 n77 0 160000
Rser78 n77 ns78 0.0116542129168
Lser78 ns78 n78 7.96875e-08
Cbase78 n78 0 1.41666666667e-11
Rbleed78 n78 0 160000
Rser79 n78 ns79 0.0116542129168
Lser79 ns79 n79 7.96875e-08
Cfixed79 n79 0 2.55e-12
Dvar79 n79 vb DVAR
Rbleed79 n79 0 160000
Rser80 n79 ns80 0.0116542129168
Lser80 ns80 n80 7.96875e-08
Cfixed80 n80 0 2.55e-12
Dvar80 n80 vb DVAR
Rbleed80 n80 0 160000
Rser81 n80 ns81 0.0116542129168
Lser81 ns81 n81 7.96875e-08
Cfixed81 n81 0 2.55e-12
Dvar81 n81 vb DVAR
Rbleed81 n81 0 160000
Rser82 n81 ns82 0.0116542129168
Lser82 ns82 n82 7.96875e-08
Cfixed82 n82 0 2.55e-12
Dvar82 n82 vb DVAR
Rbleed82 n82 0 160000
Rser83 n82 ns83 0.0116542129168
Lser83 ns83 n83 7.96875e-08
Cfixed83 n83 0 2.55e-12
Dvar83 n83 vb DVAR
Rbleed83 n83 0 160000
Rser84 n83 ns84 0.0116542129168
Lser84 ns84 n84 7.96875e-08
Cfixed84 n84 0 2.55e-12
Dvar84 n84 vb DVAR
Rbleed84 n84 0 160000
Rser85 n84 ns85 0.0116542129168
Lser85 ns85 n85 7.96875e-08
Cfixed85 n85 0 2.55e-12
Dvar85 n85 vb DVAR
Rbleed85 n85 0 160000
Rser86 n85 ns86 0.0116542129168
Lser86 ns86 n86 7.96875e-08
Cfixed86 n86 0 2.55e-12
Dvar86 n86 vb DVAR
Rbleed86 n86 0 160000
Rser87 n86 ns87 0.0116542129168
Lser87 ns87 n87 7.96875e-08
Cfixed87 n87 0 2.55e-12
Dvar87 n87 vb DVAR
Rbleed87 n87 0 160000
Rser88 n87 ns88 0.0116542129168
Lser88 ns88 n88 7.96875e-08
Cfixed88 n88 0 2.55e-12
Dvar88 n88 vb DVAR
Rbleed88 n88 0 160000
Rser89 n88 ns89 0.0116542129168
Lser89 ns89 n89 7.96875e-08
Cfixed89 n89 0 2.55e-12
Dvar89 n89 vb DVAR
Rbleed89 n89 0 160000
Rser90 n89 ns90 0.0116542129168
Lser90 ns90 n90 7.96875e-08
Cfixed90 n90 0 2.55e-12
Dvar90 n90 vb DVAR
Rbleed90 n90 0 160000
Rser91 n90 ns91 0.0116542129168
Lser91 ns91 n91 7.96875e-08
Cfixed91 n91 0 2.55e-12
Dvar91 n91 vb DVAR
Rbleed91 n91 0 160000
Rser92 n91 ns92 0.0116542129168
Lser92 ns92 n92 7.96875e-08
Cfixed92 n92 0 2.55e-12
Dvar92 n92 vb DVAR
Rbleed92 n92 0 160000
Rser93 n92 ns93 0.0116542129168
Lser93 ns93 n93 7.96875e-08
Cfixed93 n93 0 2.55e-12
Dvar93 n93 vb DVAR
Rbleed93 n93 0 160000
Rser94 n93 ns94 0.0116542129168
Lser94 ns94 n94 7.96875e-08
Cfixed94 n94 0 2.55e-12
Dvar94 n94 vb DVAR
Rbleed94 n94 0 160000
Rser95 n94 ns95 0.0116542129168
Lser95 ns95 n95 7.96875e-08
Cfixed95 n95 0 2.55e-12
Dvar95 n95 vb DVAR
Rbleed95 n95 0 160000
Rser96 n95 ns96 0.0116542129168
Lser96 ns96 n96 7.96875e-08
Cfixed96 n96 0 2.55e-12
Dvar96 n96 vb DVAR
Rbleed96 n96 0 160000
Rser97 n96 ns97 0.0116542129168
Lser97 ns97 n97 7.96875e-08
Cfixed97 n97 0 2.55e-12
Dvar97 n97 vb DVAR
Rbleed97 n97 0 160000
Rser98 n97 ns98 0.0116542129168
Lser98 ns98 n98 7.96875e-08
Cfixed98 n98 0 2.55e-12
Dvar98 n98 vb DVAR
Rbleed98 n98 0 160000
Rser99 n98 ns99 0.0116542129168
Lser99 ns99 n99 7.96875e-08
Cfixed99 n99 0 2.55e-12
Dvar99 n99 vb DVAR
Rbleed99 n99 0 160000
Rser100 n99 ns100 0.0116542129168
Lser100 ns100 n100 7.96875e-08
Cfixed100 n100 0 2.55e-12
Dvar100 n100 vb DVAR
Rbleed100 n100 0 160000
Rser101 n100 ns101 0.0116542129168
Lser101 ns101 n101 7.96875e-08
Cfixed101 n101 0 2.55e-12
Dvar101 n101 vb DVAR
Rbleed101 n101 0 160000
Rser102 n101 ns102 0.0116542129168
Lser102 ns102 n102 7.96875e-08
Cfixed102 n102 0 2.55e-12
Dvar102 n102 vb DVAR
Rbleed102 n102 0 160000
Rser103 n102 ns103 0.0116542129168
Lser103 ns103 n103 7.96875e-08
Cfixed103 n103 0 2.55e-12
Dvar103 n103 vb DVAR
Rbleed103 n103 0 160000
Rser104 n103 ns104 0.0116542129168
Lser104 ns104 n104 7.96875e-08
Cfixed104 n104 0 2.55e-12
Dvar104 n104 vb DVAR
Rbleed104 n104 0 160000
Rser105 n104 ns105 0.0116542129168
Lser105 ns105 n105 7.96875e-08
Cfixed105 n105 0 2.55e-12
Dvar105 n105 vb DVAR
Rbleed105 n105 0 160000
Rser106 n105 ns106 0.0116542129168
Lser106 ns106 n106 7.96875e-08
Cfixed106 n106 0 2.55e-12
Dvar106 n106 vb DVAR
Rbleed106 n106 0 160000
Rser107 n106 ns107 0.0116542129168
Lser107 ns107 n107 7.96875e-08
Cfixed107 n107 0 2.55e-12
Dvar107 n107 vb DVAR
Rbleed107 n107 0 160000
Rser108 n107 ns108 0.0116542129168
Lser108 ns108 n108 7.96875e-08
Cfixed108 n108 0 2.55e-12
Dvar108 n108 vb DVAR
Rbleed108 n108 0 160000
Rser109 n108 ns109 0.0116542129168
Lser109 ns109 n109 7.96875e-08
Cfixed109 n109 0 2.55e-12
Dvar109 n109 vb DVAR
Rbleed109 n109 0 160000
Rser110 n109 ns110 0.0116542129168
Lser110 ns110 n110 7.96875e-08
Cfixed110 n110 0 2.55e-12
Dvar110 n110 vb DVAR
Rbleed110 n110 0 160000
Rser111 n110 ns111 0.0116542129168
Lser111 ns111 n111 7.96875e-08
Cfixed111 n111 0 2.55e-12
Dvar111 n111 vb DVAR
Rbleed111 n111 0 160000
Rser112 n111 ns112 0.0116542129168
Lser112 ns112 n112 7.96875e-08
Cfixed112 n112 0 2.55e-12
Dvar112 n112 vb DVAR
Rbleed112 n112 0 160000
Rser113 n112 ns113 0.0116542129168
Lser113 ns113 n113 7.96875e-08
Cfixed113 n113 0 2.55e-12
Dvar113 n113 vb DVAR
Rbleed113 n113 0 160000
Rser114 n113 ns114 0.0116542129168
Lser114 ns114 n114 7.96875e-08
Cfixed114 n114 0 2.55e-12
Dvar114 n114 vb DVAR
Rbleed114 n114 0 160000
Rser115 n114 ns115 0.0116542129168
Lser115 ns115 n115 7.96875e-08
Cfixed115 n115 0 2.55e-12
Dvar115 n115 vb DVAR
Rbleed115 n115 0 160000
Rser116 n115 ns116 0.0116542129168
Lser116 ns116 n116 7.96875e-08
Cfixed116 n116 0 2.55e-12
Dvar116 n116 vb DVAR
Rbleed116 n116 0 160000
Rser117 n116 ns117 0.0116542129168
Lser117 ns117 n117 7.96875e-08
Cfixed117 n117 0 2.55e-12
Dvar117 n117 vb DVAR
Rbleed117 n117 0 160000
Rser118 n117 ns118 0.0116542129168
Lser118 ns118 n118 7.96875e-08
Cfixed118 n118 0 2.55e-12
Dvar118 n118 vb DVAR
Rbleed118 n118 0 160000
Rser119 n118 ns119 0.0116542129168
Lser119 ns119 n119 7.96875e-08
Cfixed119 n119 0 2.55e-12
Dvar119 n119 vb DVAR
Rbleed119 n119 0 160000
Rser120 n119 ns120 0.0116542129168
Lser120 ns120 n120 7.96875e-08
Cfixed120 n120 0 2.55e-12
Dvar120 n120 vb DVAR
Rbleed120 n120 0 160000
Rser121 n120 ns121 0.0116542129168
Lser121 ns121 n121 7.96875e-08
Cfixed121 n121 0 2.55e-12
Dvar121 n121 vb DVAR
Rbleed121 n121 0 160000
Rser122 n121 ns122 0.0116542129168
Lser122 ns122 n122 7.96875e-08
Cfixed122 n122 0 2.55e-12
Dvar122 n122 vb DVAR
Rbleed122 n122 0 160000
Rser123 n122 ns123 0.0116542129168
Lser123 ns123 n123 7.96875e-08
Cfixed123 n123 0 2.55e-12
Dvar123 n123 vb DVAR
Rbleed123 n123 0 160000
Rser124 n123 ns124 0.0116542129168
Lser124 ns124 n124 7.96875e-08
Cfixed124 n124 0 2.55e-12
Dvar124 n124 vb DVAR
Rbleed124 n124 0 160000
Rser125 n124 ns125 0.0116542129168
Lser125 ns125 n125 7.96875e-08
Cfixed125 n125 0 2.55e-12
Dvar125 n125 vb DVAR
Rbleed125 n125 0 160000
Rser126 n125 ns126 0.0116542129168
Lser126 ns126 n126 7.96875e-08
Cfixed126 n126 0 2.55e-12
Dvar126 n126 vb DVAR
Rbleed126 n126 0 160000
Rser127 n126 ns127 0.0116542129168
Lser127 ns127 n127 7.96875e-08
Cfixed127 n127 0 2.55e-12
Dvar127 n127 vb DVAR
Rbleed127 n127 0 160000
Rser128 n127 ns128 0.0116542129168
Lser128 ns128 n128 7.96875e-08
Cfixed128 n128 0 2.55e-12
Dvar128 n128 vb DVAR
Rbleed128 n128 0 160000
Bmag79 n79 0 I={(1.15765240371)*kmag*V(n79)*V(n79)*V(n79)/(1+(V(n79)/7.5)**2) + gcore*V(n79)}
Bmag83 n83 0 I={(1.16028955513)*kmag*V(n83)*V(n83)*V(n83)/(1+(V(n83)/7.5)**2) + gcore*V(n83)}
Bmag87 n87 0 I={(1.16277018653)*kmag*V(n87)*V(n87)*V(n87)/(1+(V(n87)/7.5)**2) + gcore*V(n87)}
Bmag91 n91 0 I={(1.16509187559)*kmag*V(n91)*V(n91)*V(n91)/(1+(V(n91)/7.5)**2) + gcore*V(n91)}
Bmag95 n95 0 I={(1.16725235525)*kmag*V(n95)*V(n95)*V(n95)/(1+(V(n95)/7.5)**2) + gcore*V(n95)}
Bmag99 n99 0 I={(1.16924951582)*kmag*V(n99)*V(n99)*V(n99)/(1+(V(n99)/7.5)**2) + gcore*V(n99)}
Bmag103 n103 0 I={(1.1710814071)*kmag*V(n103)*V(n103)*V(n103)/(1+(V(n103)/7.5)**2) + gcore*V(n103)}
Bmag107 n107 0 I={(1.1727462403)*kmag*V(n107)*V(n107)*V(n107)/(1+(V(n107)/7.5)**2) + gcore*V(n107)}
Bmag111 n111 0 I={(1.17424238972)*kmag*V(n111)*V(n111)*V(n111)/(1+(V(n111)/7.5)**2) + gcore*V(n111)}
Bmag115 n115 0 I={(1.17556839441)*kmag*V(n115)*V(n115)*V(n115)/(1+(V(n115)/7.5)**2) + gcore*V(n115)}
Bmag119 n119 0 I={(1.17672295954)*kmag*V(n119)*V(n119)*V(n119)/(1+(V(n119)/7.5)**2) + gcore*V(n119)}
Bmag123 n123 0 I={(1.1777049577)*kmag*V(n123)*V(n123)*V(n123)/(1+(V(n123)/7.5)**2) + gcore*V(n123)}
Bmag127 n127 0 I={(1.17851342998)*kmag*V(n127)*V(n127)*V(n127)/(1+(V(n127)/7.5)**2) + gcore*V(n127)}
Rext n128 ext_r 5.84074213295
Lext ext_r ext_l 2.15005587623e-07
Cext ext_l v150 5.452e-12
Rload150 v150 0 200
Rpost150 v150 post_r 3.71683590278
Lpost150 post_r post_l 3.75438847915e-07
Cpost150 post_l v150f 2.9986e-12
Rload150f v150f 0 328
Rtrap50 n128 tr50_r 13.3968807316
Ltrap50 tr50_r tr50_l 1.12579092936e-06
Ctrap50 tr50_l 0 9e-12
Rtrap100 n128 tr100_r 8.86236016069
Ltrap100 tr100_r tr100_l 3.66615047503e-07
Ctrap100 tr100_l 0 6.8e-12
.control
set filetype=ascii
set wr_singlescale
set wr_vecnames
tran 5e-10 5.5e-07 0 2e-10
wrdata h020_near_target_extraction_only_128c_75ohm_tran.csv time v(n0) v(n64) v(v150f) i(Vsrc) i(Vbias)
.endc
.end

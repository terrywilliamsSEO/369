* h021_qpm_sign_flipped_hybrid_sections_128c_75ohm
* Hybrid varactor-plus-magnetic 50/100/150 MHz refinement track.
* role=discovery; source_only=True; no direct 100/150 MHz discovery drive.
* placement=qpm_sign_flipped_hybrid_sections; magnetic_curve=soft; cleanup=extraction_plus_rejection
.option method=gear maxord=2 reltol=2e-4 abstol=1e-12 vntol=1e-6 chgtol=1e-16 itl4=280
.model DVAR D(Is=1e-15 Rs=0.34 Cjo=4.66485973932e-11 Vj=0.65 M=0.58 Bv=18 Ibv=1e-06)
.param kmag=1.845e-06
.param gcore=1.5e-07
Vbias vb 0 DC 3.4
Vsrc src 0 SIN(0 2.5 50000000)
Rsrc src n0 75
Rrawload n128 0 225
Cbase0 n0 0 1.45833333333e-11
Rbleed0 n0 0 160000
Rser1 n0 ns1 0.0116542129168
Lser1 ns1 n1 8.203125e-08
Cfixed1 n1 0 2.625e-12
Dvar1 n1 vb DVAR
Rbleed1 n1 0 160000
Rser2 n1 ns2 0.0116542129168
Lser2 ns2 n2 8.203125e-08
Cfixed2 n2 0 2.625e-12
Dvar2 n2 vb DVAR
Rbleed2 n2 0 160000
Rser3 n2 ns3 0.0116542129168
Lser3 ns3 n3 8.203125e-08
Cfixed3 n3 0 2.625e-12
Dvar3 n3 vb DVAR
Rbleed3 n3 0 160000
Rser4 n3 ns4 0.0116542129168
Lser4 ns4 n4 8.203125e-08
Cfixed4 n4 0 2.625e-12
Dvar4 n4 vb DVAR
Rbleed4 n4 0 160000
Rser5 n4 ns5 0.0116542129168
Lser5 ns5 n5 8.203125e-08
Cfixed5 n5 0 2.625e-12
Dvar5 n5 vb DVAR
Rbleed5 n5 0 160000
Rser6 n5 ns6 0.0116542129168
Lser6 ns6 n6 8.203125e-08
Cfixed6 n6 0 2.625e-12
Dvar6 n6 vb DVAR
Rbleed6 n6 0 160000
Rser7 n6 ns7 0.0116542129168
Lser7 ns7 n7 8.203125e-08
Cfixed7 n7 0 2.625e-12
Dvar7 n7 vb DVAR
Rbleed7 n7 0 160000
Rser8 n7 ns8 0.0116542129168
Lser8 ns8 n8 8.203125e-08
Cfixed8 n8 0 2.625e-12
Dvar8 n8 vb DVAR
Rbleed8 n8 0 160000
Rser9 n8 ns9 0.0116542129168
Lser9 ns9 n9 8.203125e-08
Cfixed9 n9 0 2.625e-12
Dvar9 n9 vb DVAR
Rbleed9 n9 0 160000
Rser10 n9 ns10 0.0116542129168
Lser10 ns10 n10 8.203125e-08
Cfixed10 n10 0 2.625e-12
Dvar10 n10 vb DVAR
Rbleed10 n10 0 160000
Rser11 n10 ns11 0.0116542129168
Lser11 ns11 n11 8.203125e-08
Cfixed11 n11 0 2.625e-12
Dvar11 n11 vb DVAR
Rbleed11 n11 0 160000
Rser12 n11 ns12 0.0116542129168
Lser12 ns12 n12 8.203125e-08
Cfixed12 n12 0 2.625e-12
Dvar12 n12 vb DVAR
Rbleed12 n12 0 160000
Rser13 n12 ns13 0.0116542129168
Lser13 ns13 n13 8.203125e-08
Cfixed13 n13 0 2.625e-12
Dvar13 n13 vb DVAR
Rbleed13 n13 0 160000
Rser14 n13 ns14 0.0116542129168
Lser14 ns14 n14 8.203125e-08
Cfixed14 n14 0 2.625e-12
Dvar14 n14 vb DVAR
Rbleed14 n14 0 160000
Rser15 n14 ns15 0.0116542129168
Lser15 ns15 n15 8.203125e-08
Cfixed15 n15 0 2.625e-12
Dvar15 n15 vb DVAR
Rbleed15 n15 0 160000
Rser16 n15 ns16 0.0116542129168
Lser16 ns16 n16 8.203125e-08
Cfixed16 n16 0 2.625e-12
Dvar16 n16 vb DVAR
Rbleed16 n16 0 160000
Rser17 n16 ns17 0.0116542129168
Lser17 ns17 n17 8.203125e-08
Cfixed17 n17 0 2.625e-12
Dvar17 n17 vb DVAR
Rbleed17 n17 0 160000
Rser18 n17 ns18 0.0116542129168
Lser18 ns18 n18 8.203125e-08
Cfixed18 n18 0 2.625e-12
Dvar18 n18 vb DVAR
Rbleed18 n18 0 160000
Rser19 n18 ns19 0.0116542129168
Lser19 ns19 n19 8.203125e-08
Cfixed19 n19 0 2.625e-12
Dvar19 n19 vb DVAR
Rbleed19 n19 0 160000
Rser20 n19 ns20 0.0116542129168
Lser20 ns20 n20 8.203125e-08
Cfixed20 n20 0 2.625e-12
Dvar20 n20 vb DVAR
Rbleed20 n20 0 160000
Rser21 n20 ns21 0.0116542129168
Lser21 ns21 n21 8.203125e-08
Cfixed21 n21 0 2.625e-12
Dvar21 n21 vb DVAR
Rbleed21 n21 0 160000
Rser22 n21 ns22 0.0116542129168
Lser22 ns22 n22 8.203125e-08
Cfixed22 n22 0 2.625e-12
Dvar22 n22 vb DVAR
Rbleed22 n22 0 160000
Rser23 n22 ns23 0.0116542129168
Lser23 ns23 n23 8.203125e-08
Cfixed23 n23 0 2.625e-12
Dvar23 n23 vb DVAR
Rbleed23 n23 0 160000
Rser24 n23 ns24 0.0116542129168
Lser24 ns24 n24 8.203125e-08
Cfixed24 n24 0 2.625e-12
Dvar24 n24 vb DVAR
Rbleed24 n24 0 160000
Rser25 n24 ns25 0.0116542129168
Lser25 ns25 n25 8.203125e-08
Cfixed25 n25 0 2.625e-12
Dvar25 n25 vb DVAR
Rbleed25 n25 0 160000
Rser26 n25 ns26 0.0116542129168
Lser26 ns26 n26 8.203125e-08
Cfixed26 n26 0 2.625e-12
Dvar26 n26 vb DVAR
Rbleed26 n26 0 160000
Rser27 n26 ns27 0.0116542129168
Lser27 ns27 n27 8.203125e-08
Cfixed27 n27 0 2.625e-12
Dvar27 n27 vb DVAR
Rbleed27 n27 0 160000
Rser28 n27 ns28 0.0116542129168
Lser28 ns28 n28 8.203125e-08
Cfixed28 n28 0 2.625e-12
Dvar28 n28 vb DVAR
Rbleed28 n28 0 160000
Rser29 n28 ns29 0.0116542129168
Lser29 ns29 n29 8.203125e-08
Cfixed29 n29 0 2.625e-12
Dvar29 n29 vb DVAR
Rbleed29 n29 0 160000
Rser30 n29 ns30 0.0116542129168
Lser30 ns30 n30 8.203125e-08
Cfixed30 n30 0 2.625e-12
Dvar30 n30 vb DVAR
Rbleed30 n30 0 160000
Rser31 n30 ns31 0.0116542129168
Lser31 ns31 n31 8.203125e-08
Cfixed31 n31 0 2.625e-12
Dvar31 n31 vb DVAR
Rbleed31 n31 0 160000
Rser32 n31 ns32 0.0116542129168
Lser32 ns32 n32 8.203125e-08
Cfixed32 n32 0 2.625e-12
Dvar32 n32 vb DVAR
Rbleed32 n32 0 160000
Rser33 n32 ns33 0.0116542129168
Lser33 ns33 n33 8.203125e-08
Cfixed33 n33 0 2.625e-12
Dvar33 n33 vb DVAR
Rbleed33 n33 0 160000
Rser34 n33 ns34 0.0116542129168
Lser34 ns34 n34 8.203125e-08
Cfixed34 n34 0 2.625e-12
Dvar34 n34 vb DVAR
Rbleed34 n34 0 160000
Rser35 n34 ns35 0.0116542129168
Lser35 ns35 n35 8.203125e-08
Cfixed35 n35 0 2.625e-12
Dvar35 n35 vb DVAR
Rbleed35 n35 0 160000
Rser36 n35 ns36 0.0116542129168
Lser36 ns36 n36 8.203125e-08
Cfixed36 n36 0 2.625e-12
Dvar36 n36 vb DVAR
Rbleed36 n36 0 160000
Rser37 n36 ns37 0.0116542129168
Lser37 ns37 n37 8.203125e-08
Cfixed37 n37 0 2.625e-12
Dvar37 n37 vb DVAR
Rbleed37 n37 0 160000
Rser38 n37 ns38 0.0116542129168
Lser38 ns38 n38 8.203125e-08
Cfixed38 n38 0 2.625e-12
Dvar38 n38 vb DVAR
Rbleed38 n38 0 160000
Rser39 n38 ns39 0.0116542129168
Lser39 ns39 n39 8.203125e-08
Cfixed39 n39 0 2.625e-12
Dvar39 n39 vb DVAR
Rbleed39 n39 0 160000
Rser40 n39 ns40 0.0116542129168
Lser40 ns40 n40 8.203125e-08
Cfixed40 n40 0 2.625e-12
Dvar40 n40 vb DVAR
Rbleed40 n40 0 160000
Rser41 n40 ns41 0.0116542129168
Lser41 ns41 n41 8.203125e-08
Cfixed41 n41 0 2.625e-12
Dvar41 n41 vb DVAR
Rbleed41 n41 0 160000
Rser42 n41 ns42 0.0116542129168
Lser42 ns42 n42 8.203125e-08
Cfixed42 n42 0 2.625e-12
Dvar42 n42 vb DVAR
Rbleed42 n42 0 160000
Rser43 n42 ns43 0.0116542129168
Lser43 ns43 n43 8.203125e-08
Cfixed43 n43 0 2.625e-12
Dvar43 n43 vb DVAR
Rbleed43 n43 0 160000
Rser44 n43 ns44 0.0116542129168
Lser44 ns44 n44 8.203125e-08
Cfixed44 n44 0 2.625e-12
Dvar44 n44 vb DVAR
Rbleed44 n44 0 160000
Rser45 n44 ns45 0.0116542129168
Lser45 ns45 n45 8.203125e-08
Cfixed45 n45 0 2.625e-12
Dvar45 n45 vb DVAR
Rbleed45 n45 0 160000
Rser46 n45 ns46 0.0116542129168
Lser46 ns46 n46 8.203125e-08
Cfixed46 n46 0 2.625e-12
Dvar46 n46 vb DVAR
Rbleed46 n46 0 160000
Rser47 n46 ns47 0.0116542129168
Lser47 ns47 n47 8.203125e-08
Cfixed47 n47 0 2.625e-12
Dvar47 n47 vb DVAR
Rbleed47 n47 0 160000
Rser48 n47 ns48 0.0116542129168
Lser48 ns48 n48 8.203125e-08
Cfixed48 n48 0 2.625e-12
Dvar48 n48 vb DVAR
Rbleed48 n48 0 160000
Rser49 n48 ns49 0.0116542129168
Lser49 ns49 n49 8.203125e-08
Cfixed49 n49 0 2.625e-12
Dvar49 n49 vb DVAR
Rbleed49 n49 0 160000
Rser50 n49 ns50 0.0116542129168
Lser50 ns50 n50 8.203125e-08
Cfixed50 n50 0 2.625e-12
Dvar50 n50 vb DVAR
Rbleed50 n50 0 160000
Rser51 n50 ns51 0.0116542129168
Lser51 ns51 n51 8.203125e-08
Cfixed51 n51 0 2.625e-12
Dvar51 n51 vb DVAR
Rbleed51 n51 0 160000
Rser52 n51 ns52 0.0116542129168
Lser52 ns52 n52 8.203125e-08
Cfixed52 n52 0 2.625e-12
Dvar52 n52 vb DVAR
Rbleed52 n52 0 160000
Rser53 n52 ns53 0.0116542129168
Lser53 ns53 n53 8.203125e-08
Cfixed53 n53 0 2.625e-12
Dvar53 n53 vb DVAR
Rbleed53 n53 0 160000
Rser54 n53 ns54 0.0116542129168
Lser54 ns54 n54 8.203125e-08
Cfixed54 n54 0 2.625e-12
Dvar54 n54 vb DVAR
Rbleed54 n54 0 160000
Rser55 n54 ns55 0.0116542129168
Lser55 ns55 n55 8.203125e-08
Cfixed55 n55 0 2.625e-12
Dvar55 n55 vb DVAR
Rbleed55 n55 0 160000
Rser56 n55 ns56 0.0116542129168
Lser56 ns56 n56 8.203125e-08
Cfixed56 n56 0 2.625e-12
Dvar56 n56 vb DVAR
Rbleed56 n56 0 160000
Rser57 n56 ns57 0.0116542129168
Lser57 ns57 n57 8.203125e-08
Cfixed57 n57 0 2.625e-12
Dvar57 n57 vb DVAR
Rbleed57 n57 0 160000
Rser58 n57 ns58 0.0116542129168
Lser58 ns58 n58 8.203125e-08
Cfixed58 n58 0 2.625e-12
Dvar58 n58 vb DVAR
Rbleed58 n58 0 160000
Rser59 n58 ns59 0.0116542129168
Lser59 ns59 n59 8.203125e-08
Cfixed59 n59 0 2.625e-12
Dvar59 n59 vb DVAR
Rbleed59 n59 0 160000
Rser60 n59 ns60 0.0116542129168
Lser60 ns60 n60 8.203125e-08
Cfixed60 n60 0 2.625e-12
Dvar60 n60 vb DVAR
Rbleed60 n60 0 160000
Rser61 n60 ns61 0.0116542129168
Lser61 ns61 n61 8.203125e-08
Cfixed61 n61 0 2.625e-12
Dvar61 n61 vb DVAR
Rbleed61 n61 0 160000
Rser62 n61 ns62 0.0116542129168
Lser62 ns62 n62 8.203125e-08
Cfixed62 n62 0 2.625e-12
Dvar62 n62 vb DVAR
Rbleed62 n62 0 160000
Rser63 n62 ns63 0.0116542129168
Lser63 ns63 n63 8.203125e-08
Cfixed63 n63 0 2.625e-12
Dvar63 n63 vb DVAR
Rbleed63 n63 0 160000
Rser64 n63 ns64 0.0116542129168
Lser64 ns64 n64 8.203125e-08
Cfixed64 n64 0 2.625e-12
Dvar64 n64 vb DVAR
Rbleed64 n64 0 160000
Rser65 n64 ns65 0.0116542129168
Lser65 ns65 n65 8.203125e-08
Cfixed65 n65 0 2.625e-12
Dvar65 n65 vb DVAR
Rbleed65 n65 0 160000
Rser66 n65 ns66 0.0116542129168
Lser66 ns66 n66 8.203125e-08
Cfixed66 n66 0 2.625e-12
Dvar66 n66 vb DVAR
Rbleed66 n66 0 160000
Rser67 n66 ns67 0.0116542129168
Lser67 ns67 n67 8.203125e-08
Cfixed67 n67 0 2.625e-12
Dvar67 n67 vb DVAR
Rbleed67 n67 0 160000
Rser68 n67 ns68 0.0116542129168
Lser68 ns68 n68 8.203125e-08
Cfixed68 n68 0 2.625e-12
Dvar68 n68 vb DVAR
Rbleed68 n68 0 160000
Rser69 n68 ns69 0.0116542129168
Lser69 ns69 n69 8.203125e-08
Cfixed69 n69 0 2.625e-12
Dvar69 n69 vb DVAR
Rbleed69 n69 0 160000
Rser70 n69 ns70 0.0116542129168
Lser70 ns70 n70 8.203125e-08
Cfixed70 n70 0 2.625e-12
Dvar70 n70 vb DVAR
Rbleed70 n70 0 160000
Rser71 n70 ns71 0.0116542129168
Lser71 ns71 n71 8.203125e-08
Cfixed71 n71 0 2.625e-12
Dvar71 n71 vb DVAR
Rbleed71 n71 0 160000
Rser72 n71 ns72 0.0116542129168
Lser72 ns72 n72 8.203125e-08
Cfixed72 n72 0 2.625e-12
Dvar72 n72 vb DVAR
Rbleed72 n72 0 160000
Rser73 n72 ns73 0.0116542129168
Lser73 ns73 n73 8.203125e-08
Cfixed73 n73 0 2.625e-12
Dvar73 n73 vb DVAR
Rbleed73 n73 0 160000
Rser74 n73 ns74 0.0116542129168
Lser74 ns74 n74 8.203125e-08
Cfixed74 n74 0 2.625e-12
Dvar74 n74 vb DVAR
Rbleed74 n74 0 160000
Rser75 n74 ns75 0.0116542129168
Lser75 ns75 n75 8.203125e-08
Cfixed75 n75 0 2.625e-12
Dvar75 n75 vb DVAR
Rbleed75 n75 0 160000
Rser76 n75 ns76 0.0116542129168
Lser76 ns76 n76 8.203125e-08
Cfixed76 n76 0 2.625e-12
Dvar76 n76 vb DVAR
Rbleed76 n76 0 160000
Rser77 n76 ns77 0.0116542129168
Lser77 ns77 n77 8.203125e-08
Cfixed77 n77 0 2.625e-12
Dvar77 n77 vb DVAR
Rbleed77 n77 0 160000
Rser78 n77 ns78 0.0116542129168
Lser78 ns78 n78 8.203125e-08
Cfixed78 n78 0 2.625e-12
Dvar78 n78 vb DVAR
Rbleed78 n78 0 160000
Rser79 n78 ns79 0.0116542129168
Lser79 ns79 n79 8.203125e-08
Cfixed79 n79 0 2.625e-12
Dvar79 n79 vb DVAR
Rbleed79 n79 0 160000
Rser80 n79 ns80 0.0116542129168
Lser80 ns80 n80 8.203125e-08
Cfixed80 n80 0 2.625e-12
Dvar80 n80 vb DVAR
Rbleed80 n80 0 160000
Rser81 n80 ns81 0.0116542129168
Lser81 ns81 n81 8.203125e-08
Cfixed81 n81 0 2.625e-12
Dvar81 n81 vb DVAR
Rbleed81 n81 0 160000
Rser82 n81 ns82 0.0116542129168
Lser82 ns82 n82 8.203125e-08
Cfixed82 n82 0 2.625e-12
Dvar82 n82 vb DVAR
Rbleed82 n82 0 160000
Rser83 n82 ns83 0.0116542129168
Lser83 ns83 n83 8.203125e-08
Cfixed83 n83 0 2.625e-12
Dvar83 n83 vb DVAR
Rbleed83 n83 0 160000
Rser84 n83 ns84 0.0116542129168
Lser84 ns84 n84 8.203125e-08
Cfixed84 n84 0 2.625e-12
Dvar84 n84 vb DVAR
Rbleed84 n84 0 160000
Rser85 n84 ns85 0.0116542129168
Lser85 ns85 n85 8.203125e-08
Cfixed85 n85 0 2.625e-12
Dvar85 n85 vb DVAR
Rbleed85 n85 0 160000
Rser86 n85 ns86 0.0116542129168
Lser86 ns86 n86 8.203125e-08
Cfixed86 n86 0 2.625e-12
Dvar86 n86 vb DVAR
Rbleed86 n86 0 160000
Rser87 n86 ns87 0.0116542129168
Lser87 ns87 n87 8.203125e-08
Cfixed87 n87 0 2.625e-12
Dvar87 n87 vb DVAR
Rbleed87 n87 0 160000
Rser88 n87 ns88 0.0116542129168
Lser88 ns88 n88 8.203125e-08
Cfixed88 n88 0 2.625e-12
Dvar88 n88 vb DVAR
Rbleed88 n88 0 160000
Rser89 n88 ns89 0.0116542129168
Lser89 ns89 n89 8.203125e-08
Cfixed89 n89 0 2.625e-12
Dvar89 n89 vb DVAR
Rbleed89 n89 0 160000
Rser90 n89 ns90 0.0116542129168
Lser90 ns90 n90 8.203125e-08
Cfixed90 n90 0 2.625e-12
Dvar90 n90 vb DVAR
Rbleed90 n90 0 160000
Rser91 n90 ns91 0.0116542129168
Lser91 ns91 n91 8.203125e-08
Cfixed91 n91 0 2.625e-12
Dvar91 n91 vb DVAR
Rbleed91 n91 0 160000
Rser92 n91 ns92 0.0116542129168
Lser92 ns92 n92 8.203125e-08
Cfixed92 n92 0 2.625e-12
Dvar92 n92 vb DVAR
Rbleed92 n92 0 160000
Rser93 n92 ns93 0.0116542129168
Lser93 ns93 n93 8.203125e-08
Cfixed93 n93 0 2.625e-12
Dvar93 n93 vb DVAR
Rbleed93 n93 0 160000
Rser94 n93 ns94 0.0116542129168
Lser94 ns94 n94 8.203125e-08
Cfixed94 n94 0 2.625e-12
Dvar94 n94 vb DVAR
Rbleed94 n94 0 160000
Rser95 n94 ns95 0.0116542129168
Lser95 ns95 n95 8.203125e-08
Cfixed95 n95 0 2.625e-12
Dvar95 n95 vb DVAR
Rbleed95 n95 0 160000
Rser96 n95 ns96 0.0116542129168
Lser96 ns96 n96 8.203125e-08
Cfixed96 n96 0 2.625e-12
Dvar96 n96 vb DVAR
Rbleed96 n96 0 160000
Rser97 n96 ns97 0.0116542129168
Lser97 ns97 n97 8.203125e-08
Cfixed97 n97 0 2.625e-12
Dvar97 n97 vb DVAR
Rbleed97 n97 0 160000
Rser98 n97 ns98 0.0116542129168
Lser98 ns98 n98 8.203125e-08
Cfixed98 n98 0 2.625e-12
Dvar98 n98 vb DVAR
Rbleed98 n98 0 160000
Rser99 n98 ns99 0.0116542129168
Lser99 ns99 n99 8.203125e-08
Cfixed99 n99 0 2.625e-12
Dvar99 n99 vb DVAR
Rbleed99 n99 0 160000
Rser100 n99 ns100 0.0116542129168
Lser100 ns100 n100 8.203125e-08
Cfixed100 n100 0 2.625e-12
Dvar100 n100 vb DVAR
Rbleed100 n100 0 160000
Rser101 n100 ns101 0.0116542129168
Lser101 ns101 n101 8.203125e-08
Cfixed101 n101 0 2.625e-12
Dvar101 n101 vb DVAR
Rbleed101 n101 0 160000
Rser102 n101 ns102 0.0116542129168
Lser102 ns102 n102 8.203125e-08
Cfixed102 n102 0 2.625e-12
Dvar102 n102 vb DVAR
Rbleed102 n102 0 160000
Rser103 n102 ns103 0.0116542129168
Lser103 ns103 n103 8.203125e-08
Cfixed103 n103 0 2.625e-12
Dvar103 n103 vb DVAR
Rbleed103 n103 0 160000
Rser104 n103 ns104 0.0116542129168
Lser104 ns104 n104 8.203125e-08
Cfixed104 n104 0 2.625e-12
Dvar104 n104 vb DVAR
Rbleed104 n104 0 160000
Rser105 n104 ns105 0.0116542129168
Lser105 ns105 n105 8.203125e-08
Cfixed105 n105 0 2.625e-12
Dvar105 n105 vb DVAR
Rbleed105 n105 0 160000
Rser106 n105 ns106 0.0116542129168
Lser106 ns106 n106 8.203125e-08
Cfixed106 n106 0 2.625e-12
Dvar106 n106 vb DVAR
Rbleed106 n106 0 160000
Rser107 n106 ns107 0.0116542129168
Lser107 ns107 n107 8.203125e-08
Cfixed107 n107 0 2.625e-12
Dvar107 n107 vb DVAR
Rbleed107 n107 0 160000
Rser108 n107 ns108 0.0116542129168
Lser108 ns108 n108 8.203125e-08
Cfixed108 n108 0 2.625e-12
Dvar108 n108 vb DVAR
Rbleed108 n108 0 160000
Rser109 n108 ns109 0.0116542129168
Lser109 ns109 n109 8.203125e-08
Cfixed109 n109 0 2.625e-12
Dvar109 n109 vb DVAR
Rbleed109 n109 0 160000
Rser110 n109 ns110 0.0116542129168
Lser110 ns110 n110 8.203125e-08
Cfixed110 n110 0 2.625e-12
Dvar110 n110 vb DVAR
Rbleed110 n110 0 160000
Rser111 n110 ns111 0.0116542129168
Lser111 ns111 n111 8.203125e-08
Cfixed111 n111 0 2.625e-12
Dvar111 n111 vb DVAR
Rbleed111 n111 0 160000
Rser112 n111 ns112 0.0116542129168
Lser112 ns112 n112 8.203125e-08
Cfixed112 n112 0 2.625e-12
Dvar112 n112 vb DVAR
Rbleed112 n112 0 160000
Rser113 n112 ns113 0.0116542129168
Lser113 ns113 n113 8.203125e-08
Cfixed113 n113 0 2.625e-12
Dvar113 n113 vb DVAR
Rbleed113 n113 0 160000
Rser114 n113 ns114 0.0116542129168
Lser114 ns114 n114 8.203125e-08
Cfixed114 n114 0 2.625e-12
Dvar114 n114 vb DVAR
Rbleed114 n114 0 160000
Rser115 n114 ns115 0.0116542129168
Lser115 ns115 n115 8.203125e-08
Cfixed115 n115 0 2.625e-12
Dvar115 n115 vb DVAR
Rbleed115 n115 0 160000
Rser116 n115 ns116 0.0116542129168
Lser116 ns116 n116 8.203125e-08
Cfixed116 n116 0 2.625e-12
Dvar116 n116 vb DVAR
Rbleed116 n116 0 160000
Rser117 n116 ns117 0.0116542129168
Lser117 ns117 n117 8.203125e-08
Cfixed117 n117 0 2.625e-12
Dvar117 n117 vb DVAR
Rbleed117 n117 0 160000
Rser118 n117 ns118 0.0116542129168
Lser118 ns118 n118 8.203125e-08
Cfixed118 n118 0 2.625e-12
Dvar118 n118 vb DVAR
Rbleed118 n118 0 160000
Rser119 n118 ns119 0.0116542129168
Lser119 ns119 n119 8.203125e-08
Cfixed119 n119 0 2.625e-12
Dvar119 n119 vb DVAR
Rbleed119 n119 0 160000
Rser120 n119 ns120 0.0116542129168
Lser120 ns120 n120 8.203125e-08
Cfixed120 n120 0 2.625e-12
Dvar120 n120 vb DVAR
Rbleed120 n120 0 160000
Rser121 n120 ns121 0.0116542129168
Lser121 ns121 n121 8.203125e-08
Cfixed121 n121 0 2.625e-12
Dvar121 n121 vb DVAR
Rbleed121 n121 0 160000
Rser122 n121 ns122 0.0116542129168
Lser122 ns122 n122 8.203125e-08
Cfixed122 n122 0 2.625e-12
Dvar122 n122 vb DVAR
Rbleed122 n122 0 160000
Rser123 n122 ns123 0.0116542129168
Lser123 ns123 n123 8.203125e-08
Cfixed123 n123 0 2.625e-12
Dvar123 n123 vb DVAR
Rbleed123 n123 0 160000
Rser124 n123 ns124 0.0116542129168
Lser124 ns124 n124 8.203125e-08
Cfixed124 n124 0 2.625e-12
Dvar124 n124 vb DVAR
Rbleed124 n124 0 160000
Rser125 n124 ns125 0.0116542129168
Lser125 ns125 n125 8.203125e-08
Cfixed125 n125 0 2.625e-12
Dvar125 n125 vb DVAR
Rbleed125 n125 0 160000
Rser126 n125 ns126 0.0116542129168
Lser126 ns126 n126 8.203125e-08
Cfixed126 n126 0 2.625e-12
Dvar126 n126 vb DVAR
Rbleed126 n126 0 160000
Rser127 n126 ns127 0.0116542129168
Lser127 ns127 n127 8.203125e-08
Cfixed127 n127 0 2.625e-12
Dvar127 n127 vb DVAR
Rbleed127 n127 0 160000
Rser128 n127 ns128 0.0116542129168
Lser128 ns128 n128 8.203125e-08
Cfixed128 n128 0 2.625e-12
Dvar128 n128 vb DVAR
Rbleed128 n128 0 160000
Bmag1 n1 0 I={(1.07955764767)*kmag*V(n1)*V(n1)*V(n1)/(1+(V(n1)/7.5)**2) + gcore*V(n1)}
Bmag5 n5 0 I={(1.084563729)*kmag*V(n5)*V(n5)*V(n5)/(1+(V(n5)/7.5)**2) + gcore*V(n5)}
Bmag9 n9 0 I={(1.08948723527)*kmag*V(n9)*V(n9)*V(n9)/(1+(V(n9)/7.5)**2) + gcore*V(n9)}
Bmag13 n13 0 I={(1.09432335878)*kmag*V(n13)*V(n13)*V(n13)/(1+(V(n13)/7.5)**2) + gcore*V(n13)}
Bmag17 n17 0 I={(-1.09906737714)*kmag*V(n17)*V(n17)*V(n17)/(1+(V(n17)/7.5)**2) + gcore*V(n17)}
Bmag21 n21 0 I={(-1.10371465787)*kmag*V(n21)*V(n21)*V(n21)/(1+(V(n21)/7.5)**2) + gcore*V(n21)}
Bmag25 n25 0 I={(-1.10826066301)*kmag*V(n25)*V(n25)*V(n25)/(1+(V(n25)/7.5)**2) + gcore*V(n25)}
Bmag29 n29 0 I={(-1.11270095345)*kmag*V(n29)*V(n29)*V(n29)/(1+(V(n29)/7.5)**2) + gcore*V(n29)}
Bmag33 n33 0 I={(1.11703119331)*kmag*V(n33)*V(n33)*V(n33)/(1+(V(n33)/7.5)**2) + gcore*V(n33)}
Bmag37 n37 0 I={(1.1212471542)*kmag*V(n37)*V(n37)*V(n37)/(1+(V(n37)/7.5)**2) + gcore*V(n37)}
Bmag41 n41 0 I={(1.12534471931)*kmag*V(n41)*V(n41)*V(n41)/(1+(V(n41)/7.5)**2) + gcore*V(n41)}
Bmag45 n45 0 I={(1.12931988742)*kmag*V(n45)*V(n45)*V(n45)/(1+(V(n45)/7.5)**2) + gcore*V(n45)}
Bmag49 n49 0 I={(-1.13316877686)*kmag*V(n49)*V(n49)*V(n49)/(1+(V(n49)/7.5)**2) + gcore*V(n49)}
Bmag53 n53 0 I={(-1.13688762925)*kmag*V(n53)*V(n53)*V(n53)/(1+(V(n53)/7.5)**2) + gcore*V(n53)}
Bmag57 n57 0 I={(-1.14047281319)*kmag*V(n57)*V(n57)*V(n57)/(1+(V(n57)/7.5)**2) + gcore*V(n57)}
Bmag61 n61 0 I={(-1.14392082781)*kmag*V(n61)*V(n61)*V(n61)/(1+(V(n61)/7.5)**2) + gcore*V(n61)}
Bmag65 n65 0 I={(1.14722830618)*kmag*V(n65)*V(n65)*V(n65)/(1+(V(n65)/7.5)**2) + gcore*V(n65)}
Bmag69 n69 0 I={(1.15039201862)*kmag*V(n69)*V(n69)*V(n69)/(1+(V(n69)/7.5)**2) + gcore*V(n69)}
Bmag73 n73 0 I={(1.1534088758)*kmag*V(n73)*V(n73)*V(n73)/(1+(V(n73)/7.5)**2) + gcore*V(n73)}
Bmag77 n77 0 I={(1.15627593181)*kmag*V(n77)*V(n77)*V(n77)/(1+(V(n77)/7.5)**2) + gcore*V(n77)}
Bmag81 n81 0 I={(-1.15899038703)*kmag*V(n81)*V(n81)*V(n81)/(1+(V(n81)/7.5)**2) + gcore*V(n81)}
Bmag85 n85 0 I={(-1.16154959084)*kmag*V(n85)*V(n85)*V(n85)/(1+(V(n85)/7.5)**2) + gcore*V(n85)}
Bmag89 n89 0 I={(-1.16395104421)*kmag*V(n89)*V(n89)*V(n89)/(1+(V(n89)/7.5)**2) + gcore*V(n89)}
Bmag93 n93 0 I={(-1.16619240217)*kmag*V(n93)*V(n93)*V(n93)/(1+(V(n93)/7.5)**2) + gcore*V(n93)}
Bmag97 n97 0 I={(1.16827147607)*kmag*V(n97)*V(n97)*V(n97)/(1+(V(n97)/7.5)**2) + gcore*V(n97)}
Bmag101 n101 0 I={(1.17018623572)*kmag*V(n101)*V(n101)*V(n101)/(1+(V(n101)/7.5)**2) + gcore*V(n101)}
Bmag105 n105 0 I={(1.17193481141)*kmag*V(n105)*V(n105)*V(n105)/(1+(V(n105)/7.5)**2) + gcore*V(n105)}
Bmag109 n109 0 I={(1.17351549567)*kmag*V(n109)*V(n109)*V(n109)/(1+(V(n109)/7.5)**2) + gcore*V(n109)}
Bmag113 n113 0 I={(-1.17492674499)*kmag*V(n113)*V(n113)*V(n113)/(1+(V(n113)/7.5)**2) + gcore*V(n113)}
Bmag117 n117 0 I={(-1.17616718132)*kmag*V(n117)*V(n117)*V(n117)/(1+(V(n117)/7.5)**2) + gcore*V(n117)}
Bmag121 n121 0 I={(-1.17723559338)*kmag*V(n121)*V(n121)*V(n121)/(1+(V(n121)/7.5)**2) + gcore*V(n121)}
Bmag125 n125 0 I={(-1.1781309379)*kmag*V(n125)*V(n125)*V(n125)/(1+(V(n125)/7.5)**2) + gcore*V(n125)}
Rext n128 ext_r 6.70825881736
Lext ext_r ext_l 2.17002550879e-07
Cext ext_l v150 5.358e-12
Rload150 v150 0 190
Rpost150 v150 post_r 4.61603264076
Lpost150 post_r post_l 3.8202549437e-07
Cpost150 post_l v150f 2.9469e-12
Rload150f v150f 0 296.4
Rtrap50 n128 tr50_r 17.6838825658
Ltrap50 tr50_r tr50_l 1.12579092936e-06
Ctrap50 tr50_l 0 9e-12
Rtrap100 n128 tr100_r 12.2694163818
Ltrap100 tr100_r tr100_l 3.69542102136e-07
Ctrap100 tr100_l 0 6.8e-12
.control
set filetype=ascii
set wr_singlescale
set wr_vecnames
tran 5e-10 5.5e-07 0 2e-10
wrdata h021_qpm_sign_flipped_hybrid_sections_128c_75ohm_tran.csv time v(n0) v(n64) v(v150f) i(Vsrc) i(Vbias)
.endc
.end

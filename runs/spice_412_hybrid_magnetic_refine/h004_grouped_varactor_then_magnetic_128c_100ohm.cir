* h004_grouped_varactor_then_magnetic_128c_100ohm
* Hybrid varactor-plus-magnetic 50/100/150 MHz refinement track.
* role=discovery; source_only=True; no direct 100/150 MHz discovery drive.
* placement=grouped_varactor_then_magnetic; magnetic_curve=soft; cleanup=extraction_plus_rejection
.option method=gear maxord=2 reltol=2e-4 abstol=1e-12 vntol=1e-6 chgtol=1e-16 itl4=280
.model DVAR D(Is=1e-15 Rs=0.34 Cjo=3.09879968398e-11 Vj=0.65 M=0.58 Bv=18 Ibv=1e-06)
.param kmag=1.5375e-06
.param gcore=1.5e-07
Vbias vb 0 DC 3.4
Vsrc src 0 SIN(0 2.25 50000000)
Rsrc src n0 100
Rrawload n128 0 300
Cbase0 n0 0 9.6875e-12
Rbleed0 n0 0 160000
Rser1 n0 ns1 0.0134571259295
Lser1 ns1 n1 9.6875e-08
Cfixed1 n1 0 1.74375e-12
Dvar1 n1 vb DVAR
Rbleed1 n1 0 160000
Rser2 n1 ns2 0.0134571259295
Lser2 ns2 n2 9.6875e-08
Cfixed2 n2 0 1.74375e-12
Dvar2 n2 vb DVAR
Rbleed2 n2 0 160000
Rser3 n2 ns3 0.0134571259295
Lser3 ns3 n3 9.6875e-08
Cfixed3 n3 0 1.74375e-12
Dvar3 n3 vb DVAR
Rbleed3 n3 0 160000
Rser4 n3 ns4 0.0134571259295
Lser4 ns4 n4 9.6875e-08
Cfixed4 n4 0 1.74375e-12
Dvar4 n4 vb DVAR
Rbleed4 n4 0 160000
Rser5 n4 ns5 0.0134571259295
Lser5 ns5 n5 9.6875e-08
Cfixed5 n5 0 1.74375e-12
Dvar5 n5 vb DVAR
Rbleed5 n5 0 160000
Rser6 n5 ns6 0.0134571259295
Lser6 ns6 n6 9.6875e-08
Cfixed6 n6 0 1.74375e-12
Dvar6 n6 vb DVAR
Rbleed6 n6 0 160000
Rser7 n6 ns7 0.0134571259295
Lser7 ns7 n7 9.6875e-08
Cfixed7 n7 0 1.74375e-12
Dvar7 n7 vb DVAR
Rbleed7 n7 0 160000
Rser8 n7 ns8 0.0134571259295
Lser8 ns8 n8 9.6875e-08
Cfixed8 n8 0 1.74375e-12
Dvar8 n8 vb DVAR
Rbleed8 n8 0 160000
Rser9 n8 ns9 0.0134571259295
Lser9 ns9 n9 9.6875e-08
Cfixed9 n9 0 1.74375e-12
Dvar9 n9 vb DVAR
Rbleed9 n9 0 160000
Rser10 n9 ns10 0.0134571259295
Lser10 ns10 n10 9.6875e-08
Cfixed10 n10 0 1.74375e-12
Dvar10 n10 vb DVAR
Rbleed10 n10 0 160000
Rser11 n10 ns11 0.0134571259295
Lser11 ns11 n11 9.6875e-08
Cfixed11 n11 0 1.74375e-12
Dvar11 n11 vb DVAR
Rbleed11 n11 0 160000
Rser12 n11 ns12 0.0134571259295
Lser12 ns12 n12 9.6875e-08
Cfixed12 n12 0 1.74375e-12
Dvar12 n12 vb DVAR
Rbleed12 n12 0 160000
Rser13 n12 ns13 0.0134571259295
Lser13 ns13 n13 9.6875e-08
Cfixed13 n13 0 1.74375e-12
Dvar13 n13 vb DVAR
Rbleed13 n13 0 160000
Rser14 n13 ns14 0.0134571259295
Lser14 ns14 n14 9.6875e-08
Cfixed14 n14 0 1.74375e-12
Dvar14 n14 vb DVAR
Rbleed14 n14 0 160000
Rser15 n14 ns15 0.0134571259295
Lser15 ns15 n15 9.6875e-08
Cfixed15 n15 0 1.74375e-12
Dvar15 n15 vb DVAR
Rbleed15 n15 0 160000
Rser16 n15 ns16 0.0134571259295
Lser16 ns16 n16 9.6875e-08
Cfixed16 n16 0 1.74375e-12
Dvar16 n16 vb DVAR
Rbleed16 n16 0 160000
Rser17 n16 ns17 0.0134571259295
Lser17 ns17 n17 9.6875e-08
Cfixed17 n17 0 1.74375e-12
Dvar17 n17 vb DVAR
Rbleed17 n17 0 160000
Rser18 n17 ns18 0.0134571259295
Lser18 ns18 n18 9.6875e-08
Cfixed18 n18 0 1.74375e-12
Dvar18 n18 vb DVAR
Rbleed18 n18 0 160000
Rser19 n18 ns19 0.0134571259295
Lser19 ns19 n19 9.6875e-08
Cfixed19 n19 0 1.74375e-12
Dvar19 n19 vb DVAR
Rbleed19 n19 0 160000
Rser20 n19 ns20 0.0134571259295
Lser20 ns20 n20 9.6875e-08
Cfixed20 n20 0 1.74375e-12
Dvar20 n20 vb DVAR
Rbleed20 n20 0 160000
Rser21 n20 ns21 0.0134571259295
Lser21 ns21 n21 9.6875e-08
Cfixed21 n21 0 1.74375e-12
Dvar21 n21 vb DVAR
Rbleed21 n21 0 160000
Rser22 n21 ns22 0.0134571259295
Lser22 ns22 n22 9.6875e-08
Cfixed22 n22 0 1.74375e-12
Dvar22 n22 vb DVAR
Rbleed22 n22 0 160000
Rser23 n22 ns23 0.0134571259295
Lser23 ns23 n23 9.6875e-08
Cfixed23 n23 0 1.74375e-12
Dvar23 n23 vb DVAR
Rbleed23 n23 0 160000
Rser24 n23 ns24 0.0134571259295
Lser24 ns24 n24 9.6875e-08
Cfixed24 n24 0 1.74375e-12
Dvar24 n24 vb DVAR
Rbleed24 n24 0 160000
Rser25 n24 ns25 0.0134571259295
Lser25 ns25 n25 9.6875e-08
Cfixed25 n25 0 1.74375e-12
Dvar25 n25 vb DVAR
Rbleed25 n25 0 160000
Rser26 n25 ns26 0.0134571259295
Lser26 ns26 n26 9.6875e-08
Cfixed26 n26 0 1.74375e-12
Dvar26 n26 vb DVAR
Rbleed26 n26 0 160000
Rser27 n26 ns27 0.0134571259295
Lser27 ns27 n27 9.6875e-08
Cfixed27 n27 0 1.74375e-12
Dvar27 n27 vb DVAR
Rbleed27 n27 0 160000
Rser28 n27 ns28 0.0134571259295
Lser28 ns28 n28 9.6875e-08
Cfixed28 n28 0 1.74375e-12
Dvar28 n28 vb DVAR
Rbleed28 n28 0 160000
Rser29 n28 ns29 0.0134571259295
Lser29 ns29 n29 9.6875e-08
Cfixed29 n29 0 1.74375e-12
Dvar29 n29 vb DVAR
Rbleed29 n29 0 160000
Rser30 n29 ns30 0.0134571259295
Lser30 ns30 n30 9.6875e-08
Cfixed30 n30 0 1.74375e-12
Dvar30 n30 vb DVAR
Rbleed30 n30 0 160000
Rser31 n30 ns31 0.0134571259295
Lser31 ns31 n31 9.6875e-08
Cfixed31 n31 0 1.74375e-12
Dvar31 n31 vb DVAR
Rbleed31 n31 0 160000
Rser32 n31 ns32 0.0134571259295
Lser32 ns32 n32 9.6875e-08
Cfixed32 n32 0 1.74375e-12
Dvar32 n32 vb DVAR
Rbleed32 n32 0 160000
Rser33 n32 ns33 0.0134571259295
Lser33 ns33 n33 9.6875e-08
Cfixed33 n33 0 1.74375e-12
Dvar33 n33 vb DVAR
Rbleed33 n33 0 160000
Rser34 n33 ns34 0.0134571259295
Lser34 ns34 n34 9.6875e-08
Cfixed34 n34 0 1.74375e-12
Dvar34 n34 vb DVAR
Rbleed34 n34 0 160000
Rser35 n34 ns35 0.0134571259295
Lser35 ns35 n35 9.6875e-08
Cfixed35 n35 0 1.74375e-12
Dvar35 n35 vb DVAR
Rbleed35 n35 0 160000
Rser36 n35 ns36 0.0134571259295
Lser36 ns36 n36 9.6875e-08
Cfixed36 n36 0 1.74375e-12
Dvar36 n36 vb DVAR
Rbleed36 n36 0 160000
Rser37 n36 ns37 0.0134571259295
Lser37 ns37 n37 9.6875e-08
Cfixed37 n37 0 1.74375e-12
Dvar37 n37 vb DVAR
Rbleed37 n37 0 160000
Rser38 n37 ns38 0.0134571259295
Lser38 ns38 n38 9.6875e-08
Cfixed38 n38 0 1.74375e-12
Dvar38 n38 vb DVAR
Rbleed38 n38 0 160000
Rser39 n38 ns39 0.0134571259295
Lser39 ns39 n39 9.6875e-08
Cfixed39 n39 0 1.74375e-12
Dvar39 n39 vb DVAR
Rbleed39 n39 0 160000
Rser40 n39 ns40 0.0134571259295
Lser40 ns40 n40 9.6875e-08
Cfixed40 n40 0 1.74375e-12
Dvar40 n40 vb DVAR
Rbleed40 n40 0 160000
Rser41 n40 ns41 0.0134571259295
Lser41 ns41 n41 9.6875e-08
Cfixed41 n41 0 1.74375e-12
Dvar41 n41 vb DVAR
Rbleed41 n41 0 160000
Rser42 n41 ns42 0.0134571259295
Lser42 ns42 n42 9.6875e-08
Cfixed42 n42 0 1.74375e-12
Dvar42 n42 vb DVAR
Rbleed42 n42 0 160000
Rser43 n42 ns43 0.0134571259295
Lser43 ns43 n43 9.6875e-08
Cfixed43 n43 0 1.74375e-12
Dvar43 n43 vb DVAR
Rbleed43 n43 0 160000
Rser44 n43 ns44 0.0134571259295
Lser44 ns44 n44 9.6875e-08
Cfixed44 n44 0 1.74375e-12
Dvar44 n44 vb DVAR
Rbleed44 n44 0 160000
Rser45 n44 ns45 0.0134571259295
Lser45 ns45 n45 9.6875e-08
Cfixed45 n45 0 1.74375e-12
Dvar45 n45 vb DVAR
Rbleed45 n45 0 160000
Rser46 n45 ns46 0.0134571259295
Lser46 ns46 n46 9.6875e-08
Cfixed46 n46 0 1.74375e-12
Dvar46 n46 vb DVAR
Rbleed46 n46 0 160000
Rser47 n46 ns47 0.0134571259295
Lser47 ns47 n47 9.6875e-08
Cfixed47 n47 0 1.74375e-12
Dvar47 n47 vb DVAR
Rbleed47 n47 0 160000
Rser48 n47 ns48 0.0134571259295
Lser48 ns48 n48 9.6875e-08
Cfixed48 n48 0 1.74375e-12
Dvar48 n48 vb DVAR
Rbleed48 n48 0 160000
Rser49 n48 ns49 0.0134571259295
Lser49 ns49 n49 9.6875e-08
Cfixed49 n49 0 1.74375e-12
Dvar49 n49 vb DVAR
Rbleed49 n49 0 160000
Rser50 n49 ns50 0.0134571259295
Lser50 ns50 n50 9.6875e-08
Cfixed50 n50 0 1.74375e-12
Dvar50 n50 vb DVAR
Rbleed50 n50 0 160000
Rser51 n50 ns51 0.0134571259295
Lser51 ns51 n51 9.6875e-08
Cfixed51 n51 0 1.74375e-12
Dvar51 n51 vb DVAR
Rbleed51 n51 0 160000
Rser52 n51 ns52 0.0134571259295
Lser52 ns52 n52 9.6875e-08
Cfixed52 n52 0 1.74375e-12
Dvar52 n52 vb DVAR
Rbleed52 n52 0 160000
Rser53 n52 ns53 0.0134571259295
Lser53 ns53 n53 9.6875e-08
Cfixed53 n53 0 1.74375e-12
Dvar53 n53 vb DVAR
Rbleed53 n53 0 160000
Rser54 n53 ns54 0.0134571259295
Lser54 ns54 n54 9.6875e-08
Cfixed54 n54 0 1.74375e-12
Dvar54 n54 vb DVAR
Rbleed54 n54 0 160000
Rser55 n54 ns55 0.0134571259295
Lser55 ns55 n55 9.6875e-08
Cfixed55 n55 0 1.74375e-12
Dvar55 n55 vb DVAR
Rbleed55 n55 0 160000
Rser56 n55 ns56 0.0134571259295
Lser56 ns56 n56 9.6875e-08
Cfixed56 n56 0 1.74375e-12
Dvar56 n56 vb DVAR
Rbleed56 n56 0 160000
Rser57 n56 ns57 0.0134571259295
Lser57 ns57 n57 9.6875e-08
Cfixed57 n57 0 1.74375e-12
Dvar57 n57 vb DVAR
Rbleed57 n57 0 160000
Rser58 n57 ns58 0.0134571259295
Lser58 ns58 n58 9.6875e-08
Cfixed58 n58 0 1.74375e-12
Dvar58 n58 vb DVAR
Rbleed58 n58 0 160000
Rser59 n58 ns59 0.0134571259295
Lser59 ns59 n59 9.6875e-08
Cfixed59 n59 0 1.74375e-12
Dvar59 n59 vb DVAR
Rbleed59 n59 0 160000
Rser60 n59 ns60 0.0134571259295
Lser60 ns60 n60 9.6875e-08
Cfixed60 n60 0 1.74375e-12
Dvar60 n60 vb DVAR
Rbleed60 n60 0 160000
Rser61 n60 ns61 0.0134571259295
Lser61 ns61 n61 9.6875e-08
Cfixed61 n61 0 1.74375e-12
Dvar61 n61 vb DVAR
Rbleed61 n61 0 160000
Rser62 n61 ns62 0.0134571259295
Lser62 ns62 n62 9.6875e-08
Cfixed62 n62 0 1.74375e-12
Dvar62 n62 vb DVAR
Rbleed62 n62 0 160000
Rser63 n62 ns63 0.0134571259295
Lser63 ns63 n63 9.6875e-08
Cfixed63 n63 0 1.74375e-12
Dvar63 n63 vb DVAR
Rbleed63 n63 0 160000
Rser64 n63 ns64 0.0134571259295
Lser64 ns64 n64 9.6875e-08
Cfixed64 n64 0 1.74375e-12
Dvar64 n64 vb DVAR
Rbleed64 n64 0 160000
Rser65 n64 ns65 0.0134571259295
Lser65 ns65 n65 9.6875e-08
Cfixed65 n65 0 1.74375e-12
Dvar65 n65 vb DVAR
Rbleed65 n65 0 160000
Rser66 n65 ns66 0.0134571259295
Lser66 ns66 n66 9.6875e-08
Cfixed66 n66 0 1.74375e-12
Dvar66 n66 vb DVAR
Rbleed66 n66 0 160000
Rser67 n66 ns67 0.0134571259295
Lser67 ns67 n67 9.6875e-08
Cfixed67 n67 0 1.74375e-12
Dvar67 n67 vb DVAR
Rbleed67 n67 0 160000
Rser68 n67 ns68 0.0134571259295
Lser68 ns68 n68 9.6875e-08
Cfixed68 n68 0 1.74375e-12
Dvar68 n68 vb DVAR
Rbleed68 n68 0 160000
Rser69 n68 ns69 0.0134571259295
Lser69 ns69 n69 9.6875e-08
Cfixed69 n69 0 1.74375e-12
Dvar69 n69 vb DVAR
Rbleed69 n69 0 160000
Rser70 n69 ns70 0.0134571259295
Lser70 ns70 n70 9.6875e-08
Cfixed70 n70 0 1.74375e-12
Dvar70 n70 vb DVAR
Rbleed70 n70 0 160000
Rser71 n70 ns71 0.0134571259295
Lser71 ns71 n71 9.6875e-08
Cfixed71 n71 0 1.74375e-12
Dvar71 n71 vb DVAR
Rbleed71 n71 0 160000
Rser72 n71 ns72 0.0134571259295
Lser72 ns72 n72 9.6875e-08
Cfixed72 n72 0 1.74375e-12
Dvar72 n72 vb DVAR
Rbleed72 n72 0 160000
Rser73 n72 ns73 0.0134571259295
Lser73 ns73 n73 9.6875e-08
Cfixed73 n73 0 1.74375e-12
Dvar73 n73 vb DVAR
Rbleed73 n73 0 160000
Rser74 n73 ns74 0.0134571259295
Lser74 ns74 n74 9.6875e-08
Cfixed74 n74 0 1.74375e-12
Dvar74 n74 vb DVAR
Rbleed74 n74 0 160000
Rser75 n74 ns75 0.0134571259295
Lser75 ns75 n75 9.6875e-08
Cfixed75 n75 0 1.74375e-12
Dvar75 n75 vb DVAR
Rbleed75 n75 0 160000
Rser76 n75 ns76 0.0134571259295
Lser76 ns76 n76 9.6875e-08
Cfixed76 n76 0 1.74375e-12
Dvar76 n76 vb DVAR
Rbleed76 n76 0 160000
Rser77 n76 ns77 0.0134571259295
Lser77 ns77 n77 9.6875e-08
Cfixed77 n77 0 1.74375e-12
Dvar77 n77 vb DVAR
Rbleed77 n77 0 160000
Rser78 n77 ns78 0.0134571259295
Lser78 ns78 n78 9.6875e-08
Cfixed78 n78 0 1.74375e-12
Dvar78 n78 vb DVAR
Rbleed78 n78 0 160000
Rser79 n78 ns79 0.0134571259295
Lser79 ns79 n79 9.6875e-08
Cfixed79 n79 0 1.74375e-12
Dvar79 n79 vb DVAR
Rbleed79 n79 0 160000
Rser80 n79 ns80 0.0134571259295
Lser80 ns80 n80 9.6875e-08
Cbase80 n80 0 9.6875e-12
Rbleed80 n80 0 160000
Rser81 n80 ns81 0.0134571259295
Lser81 ns81 n81 9.6875e-08
Cbase81 n81 0 9.6875e-12
Rbleed81 n81 0 160000
Rser82 n81 ns82 0.0134571259295
Lser82 ns82 n82 9.6875e-08
Cbase82 n82 0 9.6875e-12
Rbleed82 n82 0 160000
Rser83 n82 ns83 0.0134571259295
Lser83 ns83 n83 9.6875e-08
Cbase83 n83 0 9.6875e-12
Rbleed83 n83 0 160000
Rser84 n83 ns84 0.0134571259295
Lser84 ns84 n84 9.6875e-08
Cbase84 n84 0 9.6875e-12
Rbleed84 n84 0 160000
Rser85 n84 ns85 0.0134571259295
Lser85 ns85 n85 9.6875e-08
Cbase85 n85 0 9.6875e-12
Rbleed85 n85 0 160000
Rser86 n85 ns86 0.0134571259295
Lser86 ns86 n86 9.6875e-08
Cbase86 n86 0 9.6875e-12
Rbleed86 n86 0 160000
Rser87 n86 ns87 0.0134571259295
Lser87 ns87 n87 9.6875e-08
Cbase87 n87 0 9.6875e-12
Rbleed87 n87 0 160000
Rser88 n87 ns88 0.0134571259295
Lser88 ns88 n88 9.6875e-08
Cbase88 n88 0 9.6875e-12
Rbleed88 n88 0 160000
Rser89 n88 ns89 0.0134571259295
Lser89 ns89 n89 9.6875e-08
Cbase89 n89 0 9.6875e-12
Rbleed89 n89 0 160000
Rser90 n89 ns90 0.0134571259295
Lser90 ns90 n90 9.6875e-08
Cbase90 n90 0 9.6875e-12
Rbleed90 n90 0 160000
Rser91 n90 ns91 0.0134571259295
Lser91 ns91 n91 9.6875e-08
Cbase91 n91 0 9.6875e-12
Rbleed91 n91 0 160000
Rser92 n91 ns92 0.0134571259295
Lser92 ns92 n92 9.6875e-08
Cbase92 n92 0 9.6875e-12
Rbleed92 n92 0 160000
Rser93 n92 ns93 0.0134571259295
Lser93 ns93 n93 9.6875e-08
Cbase93 n93 0 9.6875e-12
Rbleed93 n93 0 160000
Rser94 n93 ns94 0.0134571259295
Lser94 ns94 n94 9.6875e-08
Cbase94 n94 0 9.6875e-12
Rbleed94 n94 0 160000
Rser95 n94 ns95 0.0134571259295
Lser95 ns95 n95 9.6875e-08
Cbase95 n95 0 9.6875e-12
Rbleed95 n95 0 160000
Rser96 n95 ns96 0.0134571259295
Lser96 ns96 n96 9.6875e-08
Cbase96 n96 0 9.6875e-12
Rbleed96 n96 0 160000
Rser97 n96 ns97 0.0134571259295
Lser97 ns97 n97 9.6875e-08
Cbase97 n97 0 9.6875e-12
Rbleed97 n97 0 160000
Rser98 n97 ns98 0.0134571259295
Lser98 ns98 n98 9.6875e-08
Cbase98 n98 0 9.6875e-12
Rbleed98 n98 0 160000
Rser99 n98 ns99 0.0134571259295
Lser99 ns99 n99 9.6875e-08
Cbase99 n99 0 9.6875e-12
Rbleed99 n99 0 160000
Rser100 n99 ns100 0.0134571259295
Lser100 ns100 n100 9.6875e-08
Cbase100 n100 0 9.6875e-12
Rbleed100 n100 0 160000
Rser101 n100 ns101 0.0134571259295
Lser101 ns101 n101 9.6875e-08
Cbase101 n101 0 9.6875e-12
Rbleed101 n101 0 160000
Rser102 n101 ns102 0.0134571259295
Lser102 ns102 n102 9.6875e-08
Cbase102 n102 0 9.6875e-12
Rbleed102 n102 0 160000
Rser103 n102 ns103 0.0134571259295
Lser103 ns103 n103 9.6875e-08
Cbase103 n103 0 9.6875e-12
Rbleed103 n103 0 160000
Rser104 n103 ns104 0.0134571259295
Lser104 ns104 n104 9.6875e-08
Cbase104 n104 0 9.6875e-12
Rbleed104 n104 0 160000
Rser105 n104 ns105 0.0134571259295
Lser105 ns105 n105 9.6875e-08
Cbase105 n105 0 9.6875e-12
Rbleed105 n105 0 160000
Rser106 n105 ns106 0.0134571259295
Lser106 ns106 n106 9.6875e-08
Cbase106 n106 0 9.6875e-12
Rbleed106 n106 0 160000
Rser107 n106 ns107 0.0134571259295
Lser107 ns107 n107 9.6875e-08
Cbase107 n107 0 9.6875e-12
Rbleed107 n107 0 160000
Rser108 n107 ns108 0.0134571259295
Lser108 ns108 n108 9.6875e-08
Cbase108 n108 0 9.6875e-12
Rbleed108 n108 0 160000
Rser109 n108 ns109 0.0134571259295
Lser109 ns109 n109 9.6875e-08
Cbase109 n109 0 9.6875e-12
Rbleed109 n109 0 160000
Rser110 n109 ns110 0.0134571259295
Lser110 ns110 n110 9.6875e-08
Cbase110 n110 0 9.6875e-12
Rbleed110 n110 0 160000
Rser111 n110 ns111 0.0134571259295
Lser111 ns111 n111 9.6875e-08
Cbase111 n111 0 9.6875e-12
Rbleed111 n111 0 160000
Rser112 n111 ns112 0.0134571259295
Lser112 ns112 n112 9.6875e-08
Cbase112 n112 0 9.6875e-12
Rbleed112 n112 0 160000
Rser113 n112 ns113 0.0134571259295
Lser113 ns113 n113 9.6875e-08
Cbase113 n113 0 9.6875e-12
Rbleed113 n113 0 160000
Rser114 n113 ns114 0.0134571259295
Lser114 ns114 n114 9.6875e-08
Cbase114 n114 0 9.6875e-12
Rbleed114 n114 0 160000
Rser115 n114 ns115 0.0134571259295
Lser115 ns115 n115 9.6875e-08
Cbase115 n115 0 9.6875e-12
Rbleed115 n115 0 160000
Rser116 n115 ns116 0.0134571259295
Lser116 ns116 n116 9.6875e-08
Cbase116 n116 0 9.6875e-12
Rbleed116 n116 0 160000
Rser117 n116 ns117 0.0134571259295
Lser117 ns117 n117 9.6875e-08
Cbase117 n117 0 9.6875e-12
Rbleed117 n117 0 160000
Rser118 n117 ns118 0.0134571259295
Lser118 ns118 n118 9.6875e-08
Cbase118 n118 0 9.6875e-12
Rbleed118 n118 0 160000
Rser119 n118 ns119 0.0134571259295
Lser119 ns119 n119 9.6875e-08
Cbase119 n119 0 9.6875e-12
Rbleed119 n119 0 160000
Rser120 n119 ns120 0.0134571259295
Lser120 ns120 n120 9.6875e-08
Cbase120 n120 0 9.6875e-12
Rbleed120 n120 0 160000
Rser121 n120 ns121 0.0134571259295
Lser121 ns121 n121 9.6875e-08
Cbase121 n121 0 9.6875e-12
Rbleed121 n121 0 160000
Rser122 n121 ns122 0.0134571259295
Lser122 ns122 n122 9.6875e-08
Cbase122 n122 0 9.6875e-12
Rbleed122 n122 0 160000
Rser123 n122 ns123 0.0134571259295
Lser123 ns123 n123 9.6875e-08
Cbase123 n123 0 9.6875e-12
Rbleed123 n123 0 160000
Rser124 n123 ns124 0.0134571259295
Lser124 ns124 n124 9.6875e-08
Cbase124 n124 0 9.6875e-12
Rbleed124 n124 0 160000
Rser125 n124 ns125 0.0134571259295
Lser125 ns125 n125 9.6875e-08
Cbase125 n125 0 9.6875e-12
Rbleed125 n125 0 160000
Rser126 n125 ns126 0.0134571259295
Lser126 ns126 n126 9.6875e-08
Cbase126 n126 0 9.6875e-12
Rbleed126 n126 0 160000
Rser127 n126 ns127 0.0134571259295
Lser127 ns127 n127 9.6875e-08
Cbase127 n127 0 9.6875e-12
Rbleed127 n127 0 160000
Rser128 n127 ns128 0.0134571259295
Lser128 ns128 n128 9.6875e-08
Cbase128 n128 0 9.6875e-12
Rbleed128 n128 0 160000
Bmag80 n80 0 I={(1.15832622708)*kmag*V(n80)*V(n80)*V(n80)/(1+(V(n80)/10)**2) + gcore*V(n80)}
Bmag84 n84 0 I={(1.16092448398)*kmag*V(n84)*V(n84)*V(n84)/(1+(V(n84)/10)**2) + gcore*V(n84)}
Bmag88 n88 0 I={(1.16336560086)*kmag*V(n88)*V(n88)*V(n88)/(1+(V(n88)/10)**2) + gcore*V(n88)}
Bmag92 n92 0 I={(1.16564719401)*kmag*V(n92)*V(n92)*V(n92)/(1+(V(n92)/10)**2) + gcore*V(n92)}
Bmag96 n96 0 I={(1.16776703547)*kmag*V(n96)*V(n96)*V(n96)/(1+(V(n96)/10)**2) + gcore*V(n96)}
Bmag100 n100 0 I={(1.16972305528)*kmag*V(n100)*V(n100)*V(n100)/(1+(V(n100)/10)**2) + gcore*V(n100)}
Bmag104 n104 0 I={(1.1715133434)*kmag*V(n104)*V(n104)*V(n104)/(1+(V(n104)/10)**2) + gcore*V(n104)}
Bmag108 n108 0 I={(1.17313615165)*kmag*V(n108)*V(n108)*V(n108)/(1+(V(n108)/10)**2) + gcore*V(n108)}
Bmag112 n112 0 I={(1.17458989539)*kmag*V(n112)*V(n112)*V(n112)/(1+(V(n112)/10)**2) + gcore*V(n112)}
Bmag116 n116 0 I={(1.17587315506)*kmag*V(n116)*V(n116)*V(n116)/(1+(V(n116)/10)**2) + gcore*V(n116)}
Bmag120 n120 0 I={(1.17698467758)*kmag*V(n120)*V(n120)*V(n120)/(1+(V(n120)/10)**2) + gcore*V(n120)}
Bmag124 n124 0 I={(1.17792337756)*kmag*V(n124)*V(n124)*V(n124)/(1+(V(n124)/10)**2) + gcore*V(n124)}
Bmag128 n128 0 I={(1.17868833839)*kmag*V(n128)*V(n128)*V(n128)/(1+(V(n128)/10)**2) + gcore*V(n128)}
Rext n128 ext_r 12.5417606849
Lext ext_r ext_l 2.3952998497e-07
Cext ext_l v150 4.7e-12
Rload150 v150 0 200
Rtrap50 n128 tr50_r 17.6838825658
Ltrap50 tr50_r tr50_l 1.12579092936e-06
Ctrap50 tr50_l 0 9e-12
Rtrap100 n128 tr100_r 12.3184940474
Ltrap100 tr100_r tr100_l 3.72504351626e-07
Ctrap100 tr100_l 0 6.8e-12
.control
set filetype=ascii
set wr_singlescale
set wr_vecnames
tran 5e-10 5.5e-07 0 2e-10
wrdata h004_grouped_varactor_then_magnetic_128c_100ohm_tran.csv time v(n0) v(n64) v(v150) i(Vsrc) i(Vbias)
.endc
.end

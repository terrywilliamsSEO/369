* phase_mismatched_hybrid_line
* Hybrid varactor-plus-magnetic 50/100/150 MHz refinement track.
* role=control; source_only=True; no direct 100/150 MHz discovery drive.
* placement=alternating_varactor_magnetic_cells; magnetic_curve=soft; cleanup=extraction_plus_rejection
.option method=gear maxord=2 reltol=2e-4 abstol=1e-12 vntol=1e-6 chgtol=1e-16 itl4=280
.model DVAR D(Is=1e-15 Rs=0.34 Cjo=5.41795556251e-11 Vj=0.65 M=0.58 Bv=18 Ibv=1e-06)
.param kmag=1.1275e-06
.param gcore=1.5e-07
Vbias vb 0 DC 3.4
Vsrc src 0 SIN(0 2.5 50000000)
Rsrc src n0 75
Rrawload n96 0 225
Cbase0 n0 0 1.69376693767e-11
Rbleed0 n0 0 160000
Rser1 n0 ns1 0.0155389505558
Lser1 ns1 n1 9.52743902439e-08
Cfixed1 n1 0 3.0487804878e-12
Dvar1 n1 vb DVAR
Rbleed1 n1 0 160000
Rser2 n1 ns2 0.0155389505558
Lser2 ns2 n2 9.52743902439e-08
Cfixed2 n2 0 3.0487804878e-12
Dvar2 n2 vb DVAR
Rbleed2 n2 0 160000
Rser3 n2 ns3 0.0155389505558
Lser3 ns3 n3 9.52743902439e-08
Cfixed3 n3 0 3.0487804878e-12
Dvar3 n3 vb DVAR
Rbleed3 n3 0 160000
Rser4 n3 ns4 0.0155389505558
Lser4 ns4 n4 9.52743902439e-08
Cfixed4 n4 0 3.0487804878e-12
Dvar4 n4 vb DVAR
Rbleed4 n4 0 160000
Rser5 n4 ns5 0.0155389505558
Lser5 ns5 n5 9.52743902439e-08
Cfixed5 n5 0 3.0487804878e-12
Dvar5 n5 vb DVAR
Rbleed5 n5 0 160000
Rser6 n5 ns6 0.0155389505558
Lser6 ns6 n6 9.52743902439e-08
Cfixed6 n6 0 3.0487804878e-12
Dvar6 n6 vb DVAR
Rbleed6 n6 0 160000
Rser7 n6 ns7 0.0155389505558
Lser7 ns7 n7 9.52743902439e-08
Cfixed7 n7 0 3.0487804878e-12
Dvar7 n7 vb DVAR
Rbleed7 n7 0 160000
Rser8 n7 ns8 0.0155389505558
Lser8 ns8 n8 9.52743902439e-08
Cfixed8 n8 0 3.0487804878e-12
Dvar8 n8 vb DVAR
Rbleed8 n8 0 160000
Rser9 n8 ns9 0.0155389505558
Lser9 ns9 n9 9.52743902439e-08
Cfixed9 n9 0 3.0487804878e-12
Dvar9 n9 vb DVAR
Rbleed9 n9 0 160000
Rser10 n9 ns10 0.0155389505558
Lser10 ns10 n10 9.52743902439e-08
Cfixed10 n10 0 3.0487804878e-12
Dvar10 n10 vb DVAR
Rbleed10 n10 0 160000
Rser11 n10 ns11 0.0155389505558
Lser11 ns11 n11 9.52743902439e-08
Cfixed11 n11 0 3.0487804878e-12
Dvar11 n11 vb DVAR
Rbleed11 n11 0 160000
Rser12 n11 ns12 0.0155389505558
Lser12 ns12 n12 9.52743902439e-08
Cfixed12 n12 0 3.0487804878e-12
Dvar12 n12 vb DVAR
Rbleed12 n12 0 160000
Rser13 n12 ns13 0.0155389505558
Lser13 ns13 n13 9.52743902439e-08
Cfixed13 n13 0 3.0487804878e-12
Dvar13 n13 vb DVAR
Rbleed13 n13 0 160000
Rser14 n13 ns14 0.0155389505558
Lser14 ns14 n14 9.52743902439e-08
Cfixed14 n14 0 3.0487804878e-12
Dvar14 n14 vb DVAR
Rbleed14 n14 0 160000
Rser15 n14 ns15 0.0155389505558
Lser15 ns15 n15 9.52743902439e-08
Cfixed15 n15 0 3.0487804878e-12
Dvar15 n15 vb DVAR
Rbleed15 n15 0 160000
Rser16 n15 ns16 0.0155389505558
Lser16 ns16 n16 9.52743902439e-08
Cfixed16 n16 0 3.0487804878e-12
Dvar16 n16 vb DVAR
Rbleed16 n16 0 160000
Rser17 n16 ns17 0.0155389505558
Lser17 ns17 n17 9.52743902439e-08
Cfixed17 n17 0 3.0487804878e-12
Dvar17 n17 vb DVAR
Rbleed17 n17 0 160000
Rser18 n17 ns18 0.0155389505558
Lser18 ns18 n18 9.52743902439e-08
Cfixed18 n18 0 3.0487804878e-12
Dvar18 n18 vb DVAR
Rbleed18 n18 0 160000
Rser19 n18 ns19 0.0155389505558
Lser19 ns19 n19 9.52743902439e-08
Cfixed19 n19 0 3.0487804878e-12
Dvar19 n19 vb DVAR
Rbleed19 n19 0 160000
Rser20 n19 ns20 0.0155389505558
Lser20 ns20 n20 9.52743902439e-08
Cfixed20 n20 0 3.0487804878e-12
Dvar20 n20 vb DVAR
Rbleed20 n20 0 160000
Rser21 n20 ns21 0.0155389505558
Lser21 ns21 n21 9.52743902439e-08
Cfixed21 n21 0 3.0487804878e-12
Dvar21 n21 vb DVAR
Rbleed21 n21 0 160000
Rser22 n21 ns22 0.0155389505558
Lser22 ns22 n22 9.52743902439e-08
Cfixed22 n22 0 3.0487804878e-12
Dvar22 n22 vb DVAR
Rbleed22 n22 0 160000
Rser23 n22 ns23 0.0155389505558
Lser23 ns23 n23 9.52743902439e-08
Cfixed23 n23 0 3.0487804878e-12
Dvar23 n23 vb DVAR
Rbleed23 n23 0 160000
Rser24 n23 ns24 0.0155389505558
Lser24 ns24 n24 9.52743902439e-08
Cfixed24 n24 0 3.0487804878e-12
Dvar24 n24 vb DVAR
Rbleed24 n24 0 160000
Rser25 n24 ns25 0.0155389505558
Lser25 ns25 n25 9.52743902439e-08
Cfixed25 n25 0 3.0487804878e-12
Dvar25 n25 vb DVAR
Rbleed25 n25 0 160000
Rser26 n25 ns26 0.0155389505558
Lser26 ns26 n26 9.52743902439e-08
Cfixed26 n26 0 3.0487804878e-12
Dvar26 n26 vb DVAR
Rbleed26 n26 0 160000
Rser27 n26 ns27 0.0155389505558
Lser27 ns27 n27 9.52743902439e-08
Cfixed27 n27 0 3.0487804878e-12
Dvar27 n27 vb DVAR
Rbleed27 n27 0 160000
Rser28 n27 ns28 0.0155389505558
Lser28 ns28 n28 9.52743902439e-08
Cfixed28 n28 0 3.0487804878e-12
Dvar28 n28 vb DVAR
Rbleed28 n28 0 160000
Rser29 n28 ns29 0.0155389505558
Lser29 ns29 n29 9.52743902439e-08
Cfixed29 n29 0 3.0487804878e-12
Dvar29 n29 vb DVAR
Rbleed29 n29 0 160000
Rser30 n29 ns30 0.0155389505558
Lser30 ns30 n30 9.52743902439e-08
Cfixed30 n30 0 3.0487804878e-12
Dvar30 n30 vb DVAR
Rbleed30 n30 0 160000
Rser31 n30 ns31 0.0155389505558
Lser31 ns31 n31 9.52743902439e-08
Cfixed31 n31 0 3.0487804878e-12
Dvar31 n31 vb DVAR
Rbleed31 n31 0 160000
Rser32 n31 ns32 0.0155389505558
Lser32 ns32 n32 9.52743902439e-08
Cfixed32 n32 0 3.0487804878e-12
Dvar32 n32 vb DVAR
Rbleed32 n32 0 160000
Rser33 n32 ns33 0.0155389505558
Lser33 ns33 n33 9.52743902439e-08
Cfixed33 n33 0 3.0487804878e-12
Dvar33 n33 vb DVAR
Rbleed33 n33 0 160000
Rser34 n33 ns34 0.0155389505558
Lser34 ns34 n34 9.52743902439e-08
Cfixed34 n34 0 3.0487804878e-12
Dvar34 n34 vb DVAR
Rbleed34 n34 0 160000
Rser35 n34 ns35 0.0155389505558
Lser35 ns35 n35 9.52743902439e-08
Cfixed35 n35 0 3.0487804878e-12
Dvar35 n35 vb DVAR
Rbleed35 n35 0 160000
Rser36 n35 ns36 0.0155389505558
Lser36 ns36 n36 9.52743902439e-08
Cfixed36 n36 0 3.0487804878e-12
Dvar36 n36 vb DVAR
Rbleed36 n36 0 160000
Rser37 n36 ns37 0.0155389505558
Lser37 ns37 n37 9.52743902439e-08
Cfixed37 n37 0 3.0487804878e-12
Dvar37 n37 vb DVAR
Rbleed37 n37 0 160000
Rser38 n37 ns38 0.0155389505558
Lser38 ns38 n38 9.52743902439e-08
Cfixed38 n38 0 3.0487804878e-12
Dvar38 n38 vb DVAR
Rbleed38 n38 0 160000
Rser39 n38 ns39 0.0155389505558
Lser39 ns39 n39 9.52743902439e-08
Cfixed39 n39 0 3.0487804878e-12
Dvar39 n39 vb DVAR
Rbleed39 n39 0 160000
Rser40 n39 ns40 0.0155389505558
Lser40 ns40 n40 9.52743902439e-08
Cfixed40 n40 0 3.0487804878e-12
Dvar40 n40 vb DVAR
Rbleed40 n40 0 160000
Rser41 n40 ns41 0.0155389505558
Lser41 ns41 n41 9.52743902439e-08
Cfixed41 n41 0 3.0487804878e-12
Dvar41 n41 vb DVAR
Rbleed41 n41 0 160000
Rser42 n41 ns42 0.0155389505558
Lser42 ns42 n42 9.52743902439e-08
Cfixed42 n42 0 3.0487804878e-12
Dvar42 n42 vb DVAR
Rbleed42 n42 0 160000
Rser43 n42 ns43 0.0155389505558
Lser43 ns43 n43 9.52743902439e-08
Cfixed43 n43 0 3.0487804878e-12
Dvar43 n43 vb DVAR
Rbleed43 n43 0 160000
Rser44 n43 ns44 0.0155389505558
Lser44 ns44 n44 9.52743902439e-08
Cfixed44 n44 0 3.0487804878e-12
Dvar44 n44 vb DVAR
Rbleed44 n44 0 160000
Rser45 n44 ns45 0.0155389505558
Lser45 ns45 n45 9.52743902439e-08
Cfixed45 n45 0 3.0487804878e-12
Dvar45 n45 vb DVAR
Rbleed45 n45 0 160000
Rser46 n45 ns46 0.0155389505558
Lser46 ns46 n46 9.52743902439e-08
Cfixed46 n46 0 3.0487804878e-12
Dvar46 n46 vb DVAR
Rbleed46 n46 0 160000
Rser47 n46 ns47 0.0155389505558
Lser47 ns47 n47 9.52743902439e-08
Cfixed47 n47 0 3.0487804878e-12
Dvar47 n47 vb DVAR
Rbleed47 n47 0 160000
Rser48 n47 ns48 0.0155389505558
Lser48 ns48 n48 9.52743902439e-08
Cfixed48 n48 0 3.0487804878e-12
Dvar48 n48 vb DVAR
Rbleed48 n48 0 160000
Rser49 n48 ns49 0.0155389505558
Lser49 ns49 n49 9.52743902439e-08
Cfixed49 n49 0 3.0487804878e-12
Dvar49 n49 vb DVAR
Rbleed49 n49 0 160000
Rser50 n49 ns50 0.0155389505558
Lser50 ns50 n50 9.52743902439e-08
Cfixed50 n50 0 3.0487804878e-12
Dvar50 n50 vb DVAR
Rbleed50 n50 0 160000
Rser51 n50 ns51 0.0155389505558
Lser51 ns51 n51 9.52743902439e-08
Cfixed51 n51 0 3.0487804878e-12
Dvar51 n51 vb DVAR
Rbleed51 n51 0 160000
Rser52 n51 ns52 0.0155389505558
Lser52 ns52 n52 9.52743902439e-08
Cfixed52 n52 0 3.0487804878e-12
Dvar52 n52 vb DVAR
Rbleed52 n52 0 160000
Rser53 n52 ns53 0.0155389505558
Lser53 ns53 n53 9.52743902439e-08
Cfixed53 n53 0 3.0487804878e-12
Dvar53 n53 vb DVAR
Rbleed53 n53 0 160000
Rser54 n53 ns54 0.0155389505558
Lser54 ns54 n54 9.52743902439e-08
Cfixed54 n54 0 3.0487804878e-12
Dvar54 n54 vb DVAR
Rbleed54 n54 0 160000
Rser55 n54 ns55 0.0155389505558
Lser55 ns55 n55 9.52743902439e-08
Cfixed55 n55 0 3.0487804878e-12
Dvar55 n55 vb DVAR
Rbleed55 n55 0 160000
Rser56 n55 ns56 0.0155389505558
Lser56 ns56 n56 9.52743902439e-08
Cfixed56 n56 0 3.0487804878e-12
Dvar56 n56 vb DVAR
Rbleed56 n56 0 160000
Rser57 n56 ns57 0.0155389505558
Lser57 ns57 n57 9.52743902439e-08
Cfixed57 n57 0 3.0487804878e-12
Dvar57 n57 vb DVAR
Rbleed57 n57 0 160000
Rser58 n57 ns58 0.0155389505558
Lser58 ns58 n58 9.52743902439e-08
Cfixed58 n58 0 3.0487804878e-12
Dvar58 n58 vb DVAR
Rbleed58 n58 0 160000
Rser59 n58 ns59 0.0155389505558
Lser59 ns59 n59 9.52743902439e-08
Cfixed59 n59 0 3.0487804878e-12
Dvar59 n59 vb DVAR
Rbleed59 n59 0 160000
Rser60 n59 ns60 0.0155389505558
Lser60 ns60 n60 9.52743902439e-08
Cfixed60 n60 0 3.0487804878e-12
Dvar60 n60 vb DVAR
Rbleed60 n60 0 160000
Rser61 n60 ns61 0.0155389505558
Lser61 ns61 n61 9.52743902439e-08
Cfixed61 n61 0 3.0487804878e-12
Dvar61 n61 vb DVAR
Rbleed61 n61 0 160000
Rser62 n61 ns62 0.0155389505558
Lser62 ns62 n62 9.52743902439e-08
Cfixed62 n62 0 3.0487804878e-12
Dvar62 n62 vb DVAR
Rbleed62 n62 0 160000
Rser63 n62 ns63 0.0155389505558
Lser63 ns63 n63 9.52743902439e-08
Cfixed63 n63 0 3.0487804878e-12
Dvar63 n63 vb DVAR
Rbleed63 n63 0 160000
Rser64 n63 ns64 0.0155389505558
Lser64 ns64 n64 9.52743902439e-08
Cfixed64 n64 0 3.0487804878e-12
Dvar64 n64 vb DVAR
Rbleed64 n64 0 160000
Rser65 n64 ns65 0.0155389505558
Lser65 ns65 n65 9.52743902439e-08
Cfixed65 n65 0 3.0487804878e-12
Dvar65 n65 vb DVAR
Rbleed65 n65 0 160000
Rser66 n65 ns66 0.0155389505558
Lser66 ns66 n66 9.52743902439e-08
Cfixed66 n66 0 3.0487804878e-12
Dvar66 n66 vb DVAR
Rbleed66 n66 0 160000
Rser67 n66 ns67 0.0155389505558
Lser67 ns67 n67 9.52743902439e-08
Cfixed67 n67 0 3.0487804878e-12
Dvar67 n67 vb DVAR
Rbleed67 n67 0 160000
Rser68 n67 ns68 0.0155389505558
Lser68 ns68 n68 9.52743902439e-08
Cfixed68 n68 0 3.0487804878e-12
Dvar68 n68 vb DVAR
Rbleed68 n68 0 160000
Rser69 n68 ns69 0.0155389505558
Lser69 ns69 n69 9.52743902439e-08
Cfixed69 n69 0 3.0487804878e-12
Dvar69 n69 vb DVAR
Rbleed69 n69 0 160000
Rser70 n69 ns70 0.0155389505558
Lser70 ns70 n70 9.52743902439e-08
Cfixed70 n70 0 3.0487804878e-12
Dvar70 n70 vb DVAR
Rbleed70 n70 0 160000
Rser71 n70 ns71 0.0155389505558
Lser71 ns71 n71 9.52743902439e-08
Cfixed71 n71 0 3.0487804878e-12
Dvar71 n71 vb DVAR
Rbleed71 n71 0 160000
Rser72 n71 ns72 0.0155389505558
Lser72 ns72 n72 9.52743902439e-08
Cfixed72 n72 0 3.0487804878e-12
Dvar72 n72 vb DVAR
Rbleed72 n72 0 160000
Rser73 n72 ns73 0.0155389505558
Lser73 ns73 n73 9.52743902439e-08
Cfixed73 n73 0 3.0487804878e-12
Dvar73 n73 vb DVAR
Rbleed73 n73 0 160000
Rser74 n73 ns74 0.0155389505558
Lser74 ns74 n74 9.52743902439e-08
Cfixed74 n74 0 3.0487804878e-12
Dvar74 n74 vb DVAR
Rbleed74 n74 0 160000
Rser75 n74 ns75 0.0155389505558
Lser75 ns75 n75 9.52743902439e-08
Cfixed75 n75 0 3.0487804878e-12
Dvar75 n75 vb DVAR
Rbleed75 n75 0 160000
Rser76 n75 ns76 0.0155389505558
Lser76 ns76 n76 9.52743902439e-08
Cfixed76 n76 0 3.0487804878e-12
Dvar76 n76 vb DVAR
Rbleed76 n76 0 160000
Rser77 n76 ns77 0.0155389505558
Lser77 ns77 n77 9.52743902439e-08
Cfixed77 n77 0 3.0487804878e-12
Dvar77 n77 vb DVAR
Rbleed77 n77 0 160000
Rser78 n77 ns78 0.0155389505558
Lser78 ns78 n78 9.52743902439e-08
Cfixed78 n78 0 3.0487804878e-12
Dvar78 n78 vb DVAR
Rbleed78 n78 0 160000
Rser79 n78 ns79 0.0155389505558
Lser79 ns79 n79 9.52743902439e-08
Cfixed79 n79 0 3.0487804878e-12
Dvar79 n79 vb DVAR
Rbleed79 n79 0 160000
Rser80 n79 ns80 0.0155389505558
Lser80 ns80 n80 9.52743902439e-08
Cfixed80 n80 0 3.0487804878e-12
Dvar80 n80 vb DVAR
Rbleed80 n80 0 160000
Rser81 n80 ns81 0.0155389505558
Lser81 ns81 n81 9.52743902439e-08
Cfixed81 n81 0 3.0487804878e-12
Dvar81 n81 vb DVAR
Rbleed81 n81 0 160000
Rser82 n81 ns82 0.0155389505558
Lser82 ns82 n82 9.52743902439e-08
Cfixed82 n82 0 3.0487804878e-12
Dvar82 n82 vb DVAR
Rbleed82 n82 0 160000
Rser83 n82 ns83 0.0155389505558
Lser83 ns83 n83 9.52743902439e-08
Cfixed83 n83 0 3.0487804878e-12
Dvar83 n83 vb DVAR
Rbleed83 n83 0 160000
Rser84 n83 ns84 0.0155389505558
Lser84 ns84 n84 9.52743902439e-08
Cfixed84 n84 0 3.0487804878e-12
Dvar84 n84 vb DVAR
Rbleed84 n84 0 160000
Rser85 n84 ns85 0.0155389505558
Lser85 ns85 n85 9.52743902439e-08
Cfixed85 n85 0 3.0487804878e-12
Dvar85 n85 vb DVAR
Rbleed85 n85 0 160000
Rser86 n85 ns86 0.0155389505558
Lser86 ns86 n86 9.52743902439e-08
Cfixed86 n86 0 3.0487804878e-12
Dvar86 n86 vb DVAR
Rbleed86 n86 0 160000
Rser87 n86 ns87 0.0155389505558
Lser87 ns87 n87 9.52743902439e-08
Cfixed87 n87 0 3.0487804878e-12
Dvar87 n87 vb DVAR
Rbleed87 n87 0 160000
Rser88 n87 ns88 0.0155389505558
Lser88 ns88 n88 9.52743902439e-08
Cfixed88 n88 0 3.0487804878e-12
Dvar88 n88 vb DVAR
Rbleed88 n88 0 160000
Rser89 n88 ns89 0.0155389505558
Lser89 ns89 n89 9.52743902439e-08
Cfixed89 n89 0 3.0487804878e-12
Dvar89 n89 vb DVAR
Rbleed89 n89 0 160000
Rser90 n89 ns90 0.0155389505558
Lser90 ns90 n90 9.52743902439e-08
Cfixed90 n90 0 3.0487804878e-12
Dvar90 n90 vb DVAR
Rbleed90 n90 0 160000
Rser91 n90 ns91 0.0155389505558
Lser91 ns91 n91 9.52743902439e-08
Cfixed91 n91 0 3.0487804878e-12
Dvar91 n91 vb DVAR
Rbleed91 n91 0 160000
Rser92 n91 ns92 0.0155389505558
Lser92 ns92 n92 9.52743902439e-08
Cfixed92 n92 0 3.0487804878e-12
Dvar92 n92 vb DVAR
Rbleed92 n92 0 160000
Rser93 n92 ns93 0.0155389505558
Lser93 ns93 n93 9.52743902439e-08
Cfixed93 n93 0 3.0487804878e-12
Dvar93 n93 vb DVAR
Rbleed93 n93 0 160000
Rser94 n93 ns94 0.0155389505558
Lser94 ns94 n94 9.52743902439e-08
Cfixed94 n94 0 3.0487804878e-12
Dvar94 n94 vb DVAR
Rbleed94 n94 0 160000
Rser95 n94 ns95 0.0155389505558
Lser95 ns95 n95 9.52743902439e-08
Cfixed95 n95 0 3.0487804878e-12
Dvar95 n95 vb DVAR
Rbleed95 n95 0 160000
Rser96 n95 ns96 0.0155389505558
Lser96 ns96 n96 9.52743902439e-08
Cfixed96 n96 0 3.0487804878e-12
Dvar96 n96 vb DVAR
Rbleed96 n96 0 160000
Bmag2 n2 0 I={(1.08165323829)*kmag*V(n2)*V(n2)*V(n2)/(1+(V(n2)/7.5)**2) + gcore*V(n2)}
Bmag18 n18 0 I={(1.10713390081)*kmag*V(n18)*V(n18)*V(n18)/(1+(V(n18)/7.5)**2) + gcore*V(n18)}
Bmag34 n34 0 I={(1.12964550401)*kmag*V(n34)*V(n34)*V(n34)/(1+(V(n34)/7.5)**2) + gcore*V(n34)}
Bmag50 n50 0 I={(1.14856417177)*kmag*V(n50)*V(n50)*V(n50)/(1+(V(n50)/7.5)**2) + gcore*V(n50)}
Bmag66 n66 0 I={(1.16336560086)*kmag*V(n66)*V(n66)*V(n66)/(1+(V(n66)/7.5)**2) + gcore*V(n66)}
Bmag82 n82 0 I={(1.17363959136)*kmag*V(n82)*V(n82)*V(n82)/(1+(V(n82)/7.5)**2) + gcore*V(n82)}
Rext n96 ext_r 10.280131709
Lext ext_r ext_l 1.60931191192e-07
Cext ext_l v150 4.7e-12
Rload150 v150 0 150
Rtrap50 n96 tr50_r 17.6838825658
Ltrap50 tr50_r tr50_l 1.12579092936e-06
Ctrap50 tr50_l 0 9e-12
Rtrap100 n96 tr100_r 13.5368066455
Ltrap100 tr100_r tr100_l 4.49830155327e-07
Ctrap100 tr100_l 0 6.8e-12
.control
set filetype=ascii
set wr_singlescale
set wr_vecnames
tran 5e-10 5.5e-07 0 2e-10
wrdata phase_mismatched_hybrid_line_tran.csv time v(n0) v(n48) v(v150) i(Vsrc) i(Vbias)
.endc
.end

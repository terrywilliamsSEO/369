* direct_4plus8_ceiling_reference
* Normalized distributed envelope ladder for 4->8->12 phase matching.
* topology=direct_4plus8_ceiling_reference role=ceiling_reference
* Source-only discovery rule: direct 8 and direct 12 drives are absent unless role=ceiling_reference.
.options reltol=1e-4 abstol=1e-8 chgtol=1e-12 method=gear maxord=2
.param tstep=0.04
.param tstop=96

Ca4r0 a4r0 0 1 ic=0
Ra4r0 a4r0 0 1e12
Ca4i0 a4i0 0 1 ic=0
Ra4i0 a4i0 0 1e12
Ca8r0 a8r0 0 1 ic=0
Ra8r0 a8r0 0 1e12
Ca8i0 a8i0 0 1 ic=0
Ra8i0 a8i0 0 1e12
Ca12r0 a12r0 0 1 ic=0
Ra12r0 a12r0 0 1e12
Ca12i0 a12i0 0 1 ic=0
Ra12i0 a12i0 0 1e12
B4r0 a4r0 0 I={-(((-0.055*(V(a4r0)))+(-0.16*(V(a4i1)-V(a4i0)))+(-0.01*((V(a4r0))*(V(a4r0))+(V(a4i0))*(V(a4i0))+(V(a8r0))*(V(a8r0))+(V(a8i0))*(V(a8i0))+(V(a12r0))*(V(a12r0))+(V(a12i0))*(V(a12i0)))*(V(a4r0)))))}
B4i0 a4i0 0 I={-(((-0.055*(V(a4i0)))+(0.16*(V(a4r1)-V(a4r0)))+(-0.01*((V(a4r0))*(V(a4r0))+(V(a4i0))*(V(a4i0))+(V(a8r0))*(V(a8r0))+(V(a8i0))*(V(a8i0))+(V(a12r0))*(V(a12r0))+(V(a12i0))*(V(a12i0)))*(V(a4i0)))))}
B8r0 a8r0 0 I={-(((-0.0594*(V(a8r0)))+(0*(V(a8i0)))+(-0.1472*(V(a8i1)-V(a8i0)))+(-0.01*((V(a4r0))*(V(a4r0))+(V(a4i0))*(V(a4i0))+(V(a8r0))*(V(a8r0))+(V(a8i0))*(V(a8i0))+(V(a12r0))*(V(a12r0))+(V(a12i0))*(V(a12i0)))*(V(a8r0)))+(0.055*((((V(a4r0))*(V(a4r0))-(V(a4i0))*(V(a4i0))))*cos((0+0*time))+((2*(V(a4r0))*(V(a4i0))))*sin((0+0*time))))))}
B8i0 a8i0 0 I={-(((-0.0594*(V(a8i0)))+(-0*(V(a8r0)))+(0.1472*(V(a8r1)-V(a8r0)))+(-0.01*((V(a4r0))*(V(a4r0))+(V(a4i0))*(V(a4i0))+(V(a8r0))*(V(a8r0))+(V(a8i0))*(V(a8i0))+(V(a12r0))*(V(a12r0))+(V(a12i0))*(V(a12i0)))*(V(a8i0)))+(0.055*(((2*(V(a4r0))*(V(a4i0))))*cos((0+0*time))-(((V(a4r0))*(V(a4r0))-(V(a4i0))*(V(a4i0))))*sin((0+0*time))))))}
B12r0 a12r0 0 I={-(((-0.0638*(V(a12r0)))+(0*(V(a12i0)))+(-0.1344*(V(a12i1)-V(a12i0)))+(-0.01*((V(a4r0))*(V(a4r0))+(V(a4i0))*(V(a4i0))+(V(a8r0))*(V(a8r0))+(V(a8i0))*(V(a8i0))+(V(a12r0))*(V(a12r0))+(V(a12i0))*(V(a12i0)))*(V(a12r0)))+(0.075*((((V(a4r0))*(V(a8r0))-(V(a4i0))*(V(a8i0))))*cos((0+0*time))+(((V(a4r0))*(V(a8i0))+(V(a4i0))*(V(a8r0))))*sin((0+0*time))))))}
B12i0 a12i0 0 I={-(((-0.0638*(V(a12i0)))+(-0*(V(a12r0)))+(0.1344*(V(a12r1)-V(a12r0)))+(-0.01*((V(a4r0))*(V(a4r0))+(V(a4i0))*(V(a4i0))+(V(a8r0))*(V(a8r0))+(V(a8i0))*(V(a8i0))+(V(a12r0))*(V(a12r0))+(V(a12i0))*(V(a12i0)))*(V(a12i0)))+(0.075*((((V(a4r0))*(V(a8i0))+(V(a4i0))*(V(a8r0))))*cos((0+0*time))-(((V(a4r0))*(V(a8r0))-(V(a4i0))*(V(a8i0))))*sin((0+0*time))))))}
Idrive4_0 a4r0 0 PWL(0 0 11.52 -0.2 78.72 -0.2 96 0)
Idrive8_0 a8r0 0 PWL(0 0 11.52 -0.1 78.72 -0.1 96 0)

Ca4r1 a4r1 0 1 ic=0
Ra4r1 a4r1 0 1e12
Ca4i1 a4i1 0 1 ic=0
Ra4i1 a4i1 0 1e12
Ca8r1 a8r1 0 1 ic=0
Ra8r1 a8r1 0 1e12
Ca8i1 a8i1 0 1 ic=0
Ra8i1 a8i1 0 1e12
Ca12r1 a12r1 0 1 ic=0
Ra12r1 a12r1 0 1e12
Ca12i1 a12i1 0 1 ic=0
Ra12i1 a12i1 0 1e12
B4r1 a4r1 0 I={-(((-0.055*(V(a4r1)))+(-0.16*(V(a4i0)-2*V(a4i1)+V(a4i2)))+(-0.01*((V(a4r1))*(V(a4r1))+(V(a4i1))*(V(a4i1))+(V(a8r1))*(V(a8r1))+(V(a8i1))*(V(a8i1))+(V(a12r1))*(V(a12r1))+(V(a12i1))*(V(a12i1)))*(V(a4r1)))))}
B4i1 a4i1 0 I={-(((-0.055*(V(a4i1)))+(0.16*(V(a4r0)-2*V(a4r1)+V(a4r2)))+(-0.01*((V(a4r1))*(V(a4r1))+(V(a4i1))*(V(a4i1))+(V(a8r1))*(V(a8r1))+(V(a8i1))*(V(a8i1))+(V(a12r1))*(V(a12r1))+(V(a12i1))*(V(a12i1)))*(V(a4i1)))))}
B8r1 a8r1 0 I={-(((-0.0594*(V(a8r1)))+(0*(V(a8i1)))+(-0.1472*(V(a8i0)-2*V(a8i1)+V(a8i2)))+(-0.01*((V(a4r1))*(V(a4r1))+(V(a4i1))*(V(a4i1))+(V(a8r1))*(V(a8r1))+(V(a8i1))*(V(a8i1))+(V(a12r1))*(V(a12r1))+(V(a12i1))*(V(a12i1)))*(V(a8r1)))+(0.055*((((V(a4r1))*(V(a4r1))-(V(a4i1))*(V(a4i1))))*cos((0+0*time))+((2*(V(a4r1))*(V(a4i1))))*sin((0+0*time))))))}
B8i1 a8i1 0 I={-(((-0.0594*(V(a8i1)))+(-0*(V(a8r1)))+(0.1472*(V(a8r0)-2*V(a8r1)+V(a8r2)))+(-0.01*((V(a4r1))*(V(a4r1))+(V(a4i1))*(V(a4i1))+(V(a8r1))*(V(a8r1))+(V(a8i1))*(V(a8i1))+(V(a12r1))*(V(a12r1))+(V(a12i1))*(V(a12i1)))*(V(a8i1)))+(0.055*(((2*(V(a4r1))*(V(a4i1))))*cos((0+0*time))-(((V(a4r1))*(V(a4r1))-(V(a4i1))*(V(a4i1))))*sin((0+0*time))))))}
B12r1 a12r1 0 I={-(((-0.0638*(V(a12r1)))+(0*(V(a12i1)))+(-0.1344*(V(a12i0)-2*V(a12i1)+V(a12i2)))+(-0.01*((V(a4r1))*(V(a4r1))+(V(a4i1))*(V(a4i1))+(V(a8r1))*(V(a8r1))+(V(a8i1))*(V(a8i1))+(V(a12r1))*(V(a12r1))+(V(a12i1))*(V(a12i1)))*(V(a12r1)))+(0.075*((((V(a4r1))*(V(a8r1))-(V(a4i1))*(V(a8i1))))*cos((0+0*time))+(((V(a4r1))*(V(a8i1))+(V(a4i1))*(V(a8r1))))*sin((0+0*time))))))}
B12i1 a12i1 0 I={-(((-0.0638*(V(a12i1)))+(-0*(V(a12r1)))+(0.1344*(V(a12r0)-2*V(a12r1)+V(a12r2)))+(-0.01*((V(a4r1))*(V(a4r1))+(V(a4i1))*(V(a4i1))+(V(a8r1))*(V(a8r1))+(V(a8i1))*(V(a8i1))+(V(a12r1))*(V(a12r1))+(V(a12i1))*(V(a12i1)))*(V(a12i1)))+(0.075*((((V(a4r1))*(V(a8i1))+(V(a4i1))*(V(a8r1))))*cos((0+0*time))-(((V(a4r1))*(V(a8r1))-(V(a4i1))*(V(a8i1))))*sin((0+0*time))))))}
Idrive4_1 a4r1 0 PWL(0 0 11.52 -0.172540683757 78.72 -0.172540683757 96 0)
Idrive8_1 a8r1 0 PWL(0 0 11.52 -0.0862703418784 78.72 -0.0862703418784 96 0)

Ca4r2 a4r2 0 1 ic=0
Ra4r2 a4r2 0 1e12
Ca4i2 a4i2 0 1 ic=0
Ra4i2 a4i2 0 1e12
Ca8r2 a8r2 0 1 ic=0
Ra8r2 a8r2 0 1e12
Ca8i2 a8i2 0 1 ic=0
Ra8i2 a8i2 0 1e12
Ca12r2 a12r2 0 1 ic=0
Ra12r2 a12r2 0 1e12
Ca12i2 a12i2 0 1 ic=0
Ra12i2 a12i2 0 1e12
B4r2 a4r2 0 I={-(((-0.055*(V(a4r2)))+(-0.16*(V(a4i1)-2*V(a4i2)+V(a4i3)))+(-0.01*((V(a4r2))*(V(a4r2))+(V(a4i2))*(V(a4i2))+(V(a8r2))*(V(a8r2))+(V(a8i2))*(V(a8i2))+(V(a12r2))*(V(a12r2))+(V(a12i2))*(V(a12i2)))*(V(a4r2)))))}
B4i2 a4i2 0 I={-(((-0.055*(V(a4i2)))+(0.16*(V(a4r1)-2*V(a4r2)+V(a4r3)))+(-0.01*((V(a4r2))*(V(a4r2))+(V(a4i2))*(V(a4i2))+(V(a8r2))*(V(a8r2))+(V(a8i2))*(V(a8i2))+(V(a12r2))*(V(a12r2))+(V(a12i2))*(V(a12i2)))*(V(a4i2)))))}
B8r2 a8r2 0 I={-(((-0.0594*(V(a8r2)))+(0*(V(a8i2)))+(-0.1472*(V(a8i1)-2*V(a8i2)+V(a8i3)))+(-0.01*((V(a4r2))*(V(a4r2))+(V(a4i2))*(V(a4i2))+(V(a8r2))*(V(a8r2))+(V(a8i2))*(V(a8i2))+(V(a12r2))*(V(a12r2))+(V(a12i2))*(V(a12i2)))*(V(a8r2)))+(0.055*((((V(a4r2))*(V(a4r2))-(V(a4i2))*(V(a4i2))))*cos((0+0*time))+((2*(V(a4r2))*(V(a4i2))))*sin((0+0*time))))))}
B8i2 a8i2 0 I={-(((-0.0594*(V(a8i2)))+(-0*(V(a8r2)))+(0.1472*(V(a8r1)-2*V(a8r2)+V(a8r3)))+(-0.01*((V(a4r2))*(V(a4r2))+(V(a4i2))*(V(a4i2))+(V(a8r2))*(V(a8r2))+(V(a8i2))*(V(a8i2))+(V(a12r2))*(V(a12r2))+(V(a12i2))*(V(a12i2)))*(V(a8i2)))+(0.055*(((2*(V(a4r2))*(V(a4i2))))*cos((0+0*time))-(((V(a4r2))*(V(a4r2))-(V(a4i2))*(V(a4i2))))*sin((0+0*time))))))}
B12r2 a12r2 0 I={-(((-0.0638*(V(a12r2)))+(0*(V(a12i2)))+(-0.1344*(V(a12i1)-2*V(a12i2)+V(a12i3)))+(-0.01*((V(a4r2))*(V(a4r2))+(V(a4i2))*(V(a4i2))+(V(a8r2))*(V(a8r2))+(V(a8i2))*(V(a8i2))+(V(a12r2))*(V(a12r2))+(V(a12i2))*(V(a12i2)))*(V(a12r2)))+(0.075*((((V(a4r2))*(V(a8r2))-(V(a4i2))*(V(a8i2))))*cos((0+0*time))+(((V(a4r2))*(V(a8i2))+(V(a4i2))*(V(a8r2))))*sin((0+0*time))))))}
B12i2 a12i2 0 I={-(((-0.0638*(V(a12i2)))+(-0*(V(a12r2)))+(0.1344*(V(a12r1)-2*V(a12r2)+V(a12r3)))+(-0.01*((V(a4r2))*(V(a4r2))+(V(a4i2))*(V(a4i2))+(V(a8r2))*(V(a8r2))+(V(a8i2))*(V(a8i2))+(V(a12r2))*(V(a12r2))+(V(a12i2))*(V(a12i2)))*(V(a12i2)))+(0.075*((((V(a4r2))*(V(a8i2))+(V(a4i2))*(V(a8r2))))*cos((0+0*time))-(((V(a4r2))*(V(a8r2))-(V(a4i2))*(V(a8i2))))*sin((0+0*time))))))}
Idrive4_2 a4r2 0 PWL(0 0 11.52 -0.110783752611 78.72 -0.110783752611 96 0)
Idrive8_2 a8r2 0 PWL(0 0 11.52 -0.0553918763053 78.72 -0.0553918763053 96 0)

Ca4r3 a4r3 0 1 ic=0
Ra4r3 a4r3 0 1e12
Ca4i3 a4i3 0 1 ic=0
Ra4i3 a4i3 0 1e12
Ca8r3 a8r3 0 1 ic=0
Ra8r3 a8r3 0 1e12
Ca8i3 a8i3 0 1 ic=0
Ra8i3 a8i3 0 1e12
Ca12r3 a12r3 0 1 ic=0
Ra12r3 a12r3 0 1e12
Ca12i3 a12i3 0 1 ic=0
Ra12i3 a12i3 0 1e12
B4r3 a4r3 0 I={-(((-0.055*(V(a4r3)))+(-0.16*(V(a4i2)-2*V(a4i3)+V(a4i4)))+(-0.01*((V(a4r3))*(V(a4r3))+(V(a4i3))*(V(a4i3))+(V(a8r3))*(V(a8r3))+(V(a8i3))*(V(a8i3))+(V(a12r3))*(V(a12r3))+(V(a12i3))*(V(a12i3)))*(V(a4r3)))))}
B4i3 a4i3 0 I={-(((-0.055*(V(a4i3)))+(0.16*(V(a4r2)-2*V(a4r3)+V(a4r4)))+(-0.01*((V(a4r3))*(V(a4r3))+(V(a4i3))*(V(a4i3))+(V(a8r3))*(V(a8r3))+(V(a8i3))*(V(a8i3))+(V(a12r3))*(V(a12r3))+(V(a12i3))*(V(a12i3)))*(V(a4i3)))))}
B8r3 a8r3 0 I={-(((-0.0594*(V(a8r3)))+(0*(V(a8i3)))+(-0.1472*(V(a8i2)-2*V(a8i3)+V(a8i4)))+(-0.01*((V(a4r3))*(V(a4r3))+(V(a4i3))*(V(a4i3))+(V(a8r3))*(V(a8r3))+(V(a8i3))*(V(a8i3))+(V(a12r3))*(V(a12r3))+(V(a12i3))*(V(a12i3)))*(V(a8r3)))+(0.055*((((V(a4r3))*(V(a4r3))-(V(a4i3))*(V(a4i3))))*cos((0+0*time))+((2*(V(a4r3))*(V(a4i3))))*sin((0+0*time))))))}
B8i3 a8i3 0 I={-(((-0.0594*(V(a8i3)))+(-0*(V(a8r3)))+(0.1472*(V(a8r2)-2*V(a8r3)+V(a8r4)))+(-0.01*((V(a4r3))*(V(a4r3))+(V(a4i3))*(V(a4i3))+(V(a8r3))*(V(a8r3))+(V(a8i3))*(V(a8i3))+(V(a12r3))*(V(a12r3))+(V(a12i3))*(V(a12i3)))*(V(a8i3)))+(0.055*(((2*(V(a4r3))*(V(a4i3))))*cos((0+0*time))-(((V(a4r3))*(V(a4r3))-(V(a4i3))*(V(a4i3))))*sin((0+0*time))))))}
B12r3 a12r3 0 I={-(((-0.0638*(V(a12r3)))+(0*(V(a12i3)))+(-0.1344*(V(a12i2)-2*V(a12i3)+V(a12i4)))+(-0.01*((V(a4r3))*(V(a4r3))+(V(a4i3))*(V(a4i3))+(V(a8r3))*(V(a8r3))+(V(a8i3))*(V(a8i3))+(V(a12r3))*(V(a12r3))+(V(a12i3))*(V(a12i3)))*(V(a12r3)))+(0.075*((((V(a4r3))*(V(a8r3))-(V(a4i3))*(V(a8i3))))*cos((0+0*time))+(((V(a4r3))*(V(a8i3))+(V(a4i3))*(V(a8r3))))*sin((0+0*time))))))}
B12i3 a12i3 0 I={-(((-0.0638*(V(a12i3)))+(-0*(V(a12r3)))+(0.1344*(V(a12r2)-2*V(a12r3)+V(a12r4)))+(-0.01*((V(a4r3))*(V(a4r3))+(V(a4i3))*(V(a4i3))+(V(a8r3))*(V(a8r3))+(V(a8i3))*(V(a8i3))+(V(a12r3))*(V(a12r3))+(V(a12i3))*(V(a12i3)))*(V(a12i3)))+(0.075*((((V(a4r3))*(V(a8i3))+(V(a4i3))*(V(a8r3))))*cos((0+0*time))-(((V(a4r3))*(V(a8r3))-(V(a4i3))*(V(a8i3))))*sin((0+0*time))))))}
Idrive4_3 a4r3 0 PWL(0 0 11.52 -0.0529399671549 78.72 -0.0529399671549 96 0)
Idrive8_3 a8r3 0 PWL(0 0 11.52 -0.0264699835775 78.72 -0.0264699835775 96 0)

Ca4r4 a4r4 0 1 ic=0
Ra4r4 a4r4 0 1e12
Ca4i4 a4i4 0 1 ic=0
Ra4i4 a4i4 0 1e12
Ca8r4 a8r4 0 1 ic=0
Ra8r4 a8r4 0 1e12
Ca8i4 a8i4 0 1 ic=0
Ra8i4 a8i4 0 1e12
Ca12r4 a12r4 0 1 ic=0
Ra12r4 a12r4 0 1e12
Ca12i4 a12i4 0 1 ic=0
Ra12i4 a12i4 0 1e12
B4r4 a4r4 0 I={-(((-0.055*(V(a4r4)))+(-0.16*(V(a4i3)-2*V(a4i4)+V(a4i5)))+(-0.01*((V(a4r4))*(V(a4r4))+(V(a4i4))*(V(a4i4))+(V(a8r4))*(V(a8r4))+(V(a8i4))*(V(a8i4))+(V(a12r4))*(V(a12r4))+(V(a12i4))*(V(a12i4)))*(V(a4r4)))))}
B4i4 a4i4 0 I={-(((-0.055*(V(a4i4)))+(0.16*(V(a4r3)-2*V(a4r4)+V(a4r5)))+(-0.01*((V(a4r4))*(V(a4r4))+(V(a4i4))*(V(a4i4))+(V(a8r4))*(V(a8r4))+(V(a8i4))*(V(a8i4))+(V(a12r4))*(V(a12r4))+(V(a12i4))*(V(a12i4)))*(V(a4i4)))))}
B8r4 a8r4 0 I={-(((-0.0594*(V(a8r4)))+(0*(V(a8i4)))+(-0.1472*(V(a8i3)-2*V(a8i4)+V(a8i5)))+(-0.01*((V(a4r4))*(V(a4r4))+(V(a4i4))*(V(a4i4))+(V(a8r4))*(V(a8r4))+(V(a8i4))*(V(a8i4))+(V(a12r4))*(V(a12r4))+(V(a12i4))*(V(a12i4)))*(V(a8r4)))+(0.055*((((V(a4r4))*(V(a4r4))-(V(a4i4))*(V(a4i4))))*cos((0+0*time))+((2*(V(a4r4))*(V(a4i4))))*sin((0+0*time))))))}
B8i4 a8i4 0 I={-(((-0.0594*(V(a8i4)))+(-0*(V(a8r4)))+(0.1472*(V(a8r3)-2*V(a8r4)+V(a8r5)))+(-0.01*((V(a4r4))*(V(a4r4))+(V(a4i4))*(V(a4i4))+(V(a8r4))*(V(a8r4))+(V(a8i4))*(V(a8i4))+(V(a12r4))*(V(a12r4))+(V(a12i4))*(V(a12i4)))*(V(a8i4)))+(0.055*(((2*(V(a4r4))*(V(a4i4))))*cos((0+0*time))-(((V(a4r4))*(V(a4r4))-(V(a4i4))*(V(a4i4))))*sin((0+0*time))))))}
B12r4 a12r4 0 I={-(((-0.0638*(V(a12r4)))+(0*(V(a12i4)))+(-0.1344*(V(a12i3)-2*V(a12i4)+V(a12i5)))+(-0.01*((V(a4r4))*(V(a4r4))+(V(a4i4))*(V(a4i4))+(V(a8r4))*(V(a8r4))+(V(a8i4))*(V(a8i4))+(V(a12r4))*(V(a12r4))+(V(a12i4))*(V(a12i4)))*(V(a12r4)))+(0.075*((((V(a4r4))*(V(a8r4))-(V(a4i4))*(V(a8i4))))*cos((0+0*time))+(((V(a4r4))*(V(a8i4))+(V(a4i4))*(V(a8r4))))*sin((0+0*time))))))}
B12i4 a12i4 0 I={-(((-0.0638*(V(a12i4)))+(-0*(V(a12r4)))+(0.1344*(V(a12r3)-2*V(a12r4)+V(a12r5)))+(-0.01*((V(a4r4))*(V(a4r4))+(V(a4i4))*(V(a4i4))+(V(a8r4))*(V(a8r4))+(V(a8i4))*(V(a8i4))+(V(a12r4))*(V(a12r4))+(V(a12i4))*(V(a12i4)))*(V(a12i4)))+(0.075*((((V(a4r4))*(V(a8i4))+(V(a4i4))*(V(a8r4))))*cos((0+0*time))-(((V(a4r4))*(V(a8r4))-(V(a4i4))*(V(a8i4))))*sin((0+0*time))))))}
Idrive4_4 a4r4 0 PWL(0 0 11.52 -0.0188284383719 78.72 -0.0188284383719 96 0)
Idrive8_4 a8r4 0 PWL(0 0 11.52 -0.00941421918595 78.72 -0.00941421918595 96 0)

Ca4r5 a4r5 0 1 ic=0
Ra4r5 a4r5 0 1e12
Ca4i5 a4i5 0 1 ic=0
Ra4i5 a4i5 0 1e12
Ca8r5 a8r5 0 1 ic=0
Ra8r5 a8r5 0 1e12
Ca8i5 a8i5 0 1 ic=0
Ra8i5 a8i5 0 1e12
Ca12r5 a12r5 0 1 ic=0
Ra12r5 a12r5 0 1e12
Ca12i5 a12i5 0 1 ic=0
Ra12i5 a12i5 0 1e12
B4r5 a4r5 0 I={-(((-0.055*(V(a4r5)))+(-0.16*(V(a4i4)-2*V(a4i5)+V(a4i6)))+(-0.01*((V(a4r5))*(V(a4r5))+(V(a4i5))*(V(a4i5))+(V(a8r5))*(V(a8r5))+(V(a8i5))*(V(a8i5))+(V(a12r5))*(V(a12r5))+(V(a12i5))*(V(a12i5)))*(V(a4r5)))))}
B4i5 a4i5 0 I={-(((-0.055*(V(a4i5)))+(0.16*(V(a4r4)-2*V(a4r5)+V(a4r6)))+(-0.01*((V(a4r5))*(V(a4r5))+(V(a4i5))*(V(a4i5))+(V(a8r5))*(V(a8r5))+(V(a8i5))*(V(a8i5))+(V(a12r5))*(V(a12r5))+(V(a12i5))*(V(a12i5)))*(V(a4i5)))))}
B8r5 a8r5 0 I={-(((-0.0594*(V(a8r5)))+(0*(V(a8i5)))+(-0.1472*(V(a8i4)-2*V(a8i5)+V(a8i6)))+(-0.01*((V(a4r5))*(V(a4r5))+(V(a4i5))*(V(a4i5))+(V(a8r5))*(V(a8r5))+(V(a8i5))*(V(a8i5))+(V(a12r5))*(V(a12r5))+(V(a12i5))*(V(a12i5)))*(V(a8r5)))+(0.055*((((V(a4r5))*(V(a4r5))-(V(a4i5))*(V(a4i5))))*cos((0+0*time))+((2*(V(a4r5))*(V(a4i5))))*sin((0+0*time))))))}
B8i5 a8i5 0 I={-(((-0.0594*(V(a8i5)))+(-0*(V(a8r5)))+(0.1472*(V(a8r4)-2*V(a8r5)+V(a8r6)))+(-0.01*((V(a4r5))*(V(a4r5))+(V(a4i5))*(V(a4i5))+(V(a8r5))*(V(a8r5))+(V(a8i5))*(V(a8i5))+(V(a12r5))*(V(a12r5))+(V(a12i5))*(V(a12i5)))*(V(a8i5)))+(0.055*(((2*(V(a4r5))*(V(a4i5))))*cos((0+0*time))-(((V(a4r5))*(V(a4r5))-(V(a4i5))*(V(a4i5))))*sin((0+0*time))))))}
B12r5 a12r5 0 I={-(((-0.0638*(V(a12r5)))+(0*(V(a12i5)))+(-0.1344*(V(a12i4)-2*V(a12i5)+V(a12i6)))+(-0.01*((V(a4r5))*(V(a4r5))+(V(a4i5))*(V(a4i5))+(V(a8r5))*(V(a8r5))+(V(a8i5))*(V(a8i5))+(V(a12r5))*(V(a12r5))+(V(a12i5))*(V(a12i5)))*(V(a12r5)))+(0.075*((((V(a4r5))*(V(a8r5))-(V(a4i5))*(V(a8i5))))*cos((0+0*time))+(((V(a4r5))*(V(a8i5))+(V(a4i5))*(V(a8r5))))*sin((0+0*time))))))}
B12i5 a12i5 0 I={-(((-0.0638*(V(a12i5)))+(-0*(V(a12r5)))+(0.1344*(V(a12r4)-2*V(a12r5)+V(a12r6)))+(-0.01*((V(a4r5))*(V(a4r5))+(V(a4i5))*(V(a4i5))+(V(a8r5))*(V(a8r5))+(V(a8i5))*(V(a8i5))+(V(a12r5))*(V(a12r5))+(V(a12i5))*(V(a12i5)))*(V(a12i5)))+(0.075*((((V(a4r5))*(V(a8i5))+(V(a4i5))*(V(a8r5))))*cos((0+0*time))-(((V(a4r5))*(V(a8r5))-(V(a4i5))*(V(a8i5))))*sin((0+0*time))))))}
Idrive4_5 a4r5 0 PWL(0 0 11.52 -0.00498388454494 78.72 -0.00498388454494 96 0)
Idrive8_5 a8r5 0 PWL(0 0 11.52 -0.00249194227247 78.72 -0.00249194227247 96 0)

Ca4r6 a4r6 0 1 ic=0
Ra4r6 a4r6 0 1e12
Ca4i6 a4i6 0 1 ic=0
Ra4i6 a4i6 0 1e12
Ca8r6 a8r6 0 1 ic=0
Ra8r6 a8r6 0 1e12
Ca8i6 a8i6 0 1 ic=0
Ra8i6 a8i6 0 1e12
Ca12r6 a12r6 0 1 ic=0
Ra12r6 a12r6 0 1e12
Ca12i6 a12i6 0 1 ic=0
Ra12i6 a12i6 0 1e12
B4r6 a4r6 0 I={-(((-0.055*(V(a4r6)))+(-0.16*(V(a4i5)-2*V(a4i6)+V(a4i7)))+(-0.01*((V(a4r6))*(V(a4r6))+(V(a4i6))*(V(a4i6))+(V(a8r6))*(V(a8r6))+(V(a8i6))*(V(a8i6))+(V(a12r6))*(V(a12r6))+(V(a12i6))*(V(a12i6)))*(V(a4r6)))))}
B4i6 a4i6 0 I={-(((-0.055*(V(a4i6)))+(0.16*(V(a4r5)-2*V(a4r6)+V(a4r7)))+(-0.01*((V(a4r6))*(V(a4r6))+(V(a4i6))*(V(a4i6))+(V(a8r6))*(V(a8r6))+(V(a8i6))*(V(a8i6))+(V(a12r6))*(V(a12r6))+(V(a12i6))*(V(a12i6)))*(V(a4i6)))))}
B8r6 a8r6 0 I={-(((-0.0594*(V(a8r6)))+(0*(V(a8i6)))+(-0.1472*(V(a8i5)-2*V(a8i6)+V(a8i7)))+(-0.01*((V(a4r6))*(V(a4r6))+(V(a4i6))*(V(a4i6))+(V(a8r6))*(V(a8r6))+(V(a8i6))*(V(a8i6))+(V(a12r6))*(V(a12r6))+(V(a12i6))*(V(a12i6)))*(V(a8r6)))+(0.055*((((V(a4r6))*(V(a4r6))-(V(a4i6))*(V(a4i6))))*cos((0+0*time))+((2*(V(a4r6))*(V(a4i6))))*sin((0+0*time))))))}
B8i6 a8i6 0 I={-(((-0.0594*(V(a8i6)))+(-0*(V(a8r6)))+(0.1472*(V(a8r5)-2*V(a8r6)+V(a8r7)))+(-0.01*((V(a4r6))*(V(a4r6))+(V(a4i6))*(V(a4i6))+(V(a8r6))*(V(a8r6))+(V(a8i6))*(V(a8i6))+(V(a12r6))*(V(a12r6))+(V(a12i6))*(V(a12i6)))*(V(a8i6)))+(0.055*(((2*(V(a4r6))*(V(a4i6))))*cos((0+0*time))-(((V(a4r6))*(V(a4r6))-(V(a4i6))*(V(a4i6))))*sin((0+0*time))))))}
B12r6 a12r6 0 I={-(((-0.0638*(V(a12r6)))+(0*(V(a12i6)))+(-0.1344*(V(a12i5)-2*V(a12i6)+V(a12i7)))+(-0.01*((V(a4r6))*(V(a4r6))+(V(a4i6))*(V(a4i6))+(V(a8r6))*(V(a8r6))+(V(a8i6))*(V(a8i6))+(V(a12r6))*(V(a12r6))+(V(a12i6))*(V(a12i6)))*(V(a12r6)))+(0.075*((((V(a4r6))*(V(a8r6))-(V(a4i6))*(V(a8i6))))*cos((0+0*time))+(((V(a4r6))*(V(a8i6))+(V(a4i6))*(V(a8r6))))*sin((0+0*time))))))}
B12i6 a12i6 0 I={-(((-0.0638*(V(a12i6)))+(-0*(V(a12r6)))+(0.1344*(V(a12r5)-2*V(a12r6)+V(a12r7)))+(-0.01*((V(a4r6))*(V(a4r6))+(V(a4i6))*(V(a4i6))+(V(a8r6))*(V(a8r6))+(V(a8i6))*(V(a8i6))+(V(a12r6))*(V(a12r6))+(V(a12i6))*(V(a12i6)))*(V(a12i6)))+(0.075*((((V(a4r6))*(V(a8i6))+(V(a4i6))*(V(a8r6))))*cos((0+0*time))-(((V(a4r6))*(V(a8r6))-(V(a4i6))*(V(a8i6))))*sin((0+0*time))))))}
Idrive4_6 a4r6 0 PWL(0 0 11.52 -0.000981848956936 78.72 -0.000981848956936 96 0)
Idrive8_6 a8r6 0 PWL(0 0 11.52 -0.000490924478468 78.72 -0.000490924478468 96 0)

Ca4r7 a4r7 0 1 ic=0
Ra4r7 a4r7 0 1e12
Ca4i7 a4i7 0 1 ic=0
Ra4i7 a4i7 0 1e12
Ca8r7 a8r7 0 1 ic=0
Ra8r7 a8r7 0 1e12
Ca8i7 a8i7 0 1 ic=0
Ra8i7 a8i7 0 1e12
Ca12r7 a12r7 0 1 ic=0
Ra12r7 a12r7 0 1e12
Ca12i7 a12i7 0 1 ic=0
Ra12i7 a12i7 0 1e12
B4r7 a4r7 0 I={-(((-0.055*(V(a4r7)))+(-0.16*(V(a4i6)-2*V(a4i7)+V(a4i8)))+(-0.01*((V(a4r7))*(V(a4r7))+(V(a4i7))*(V(a4i7))+(V(a8r7))*(V(a8r7))+(V(a8i7))*(V(a8i7))+(V(a12r7))*(V(a12r7))+(V(a12i7))*(V(a12i7)))*(V(a4r7)))))}
B4i7 a4i7 0 I={-(((-0.055*(V(a4i7)))+(0.16*(V(a4r6)-2*V(a4r7)+V(a4r8)))+(-0.01*((V(a4r7))*(V(a4r7))+(V(a4i7))*(V(a4i7))+(V(a8r7))*(V(a8r7))+(V(a8i7))*(V(a8i7))+(V(a12r7))*(V(a12r7))+(V(a12i7))*(V(a12i7)))*(V(a4i7)))))}
B8r7 a8r7 0 I={-(((-0.0594*(V(a8r7)))+(0*(V(a8i7)))+(-0.1472*(V(a8i6)-2*V(a8i7)+V(a8i8)))+(-0.01*((V(a4r7))*(V(a4r7))+(V(a4i7))*(V(a4i7))+(V(a8r7))*(V(a8r7))+(V(a8i7))*(V(a8i7))+(V(a12r7))*(V(a12r7))+(V(a12i7))*(V(a12i7)))*(V(a8r7)))+(0.055*((((V(a4r7))*(V(a4r7))-(V(a4i7))*(V(a4i7))))*cos((0+0*time))+((2*(V(a4r7))*(V(a4i7))))*sin((0+0*time))))))}
B8i7 a8i7 0 I={-(((-0.0594*(V(a8i7)))+(-0*(V(a8r7)))+(0.1472*(V(a8r6)-2*V(a8r7)+V(a8r8)))+(-0.01*((V(a4r7))*(V(a4r7))+(V(a4i7))*(V(a4i7))+(V(a8r7))*(V(a8r7))+(V(a8i7))*(V(a8i7))+(V(a12r7))*(V(a12r7))+(V(a12i7))*(V(a12i7)))*(V(a8i7)))+(0.055*(((2*(V(a4r7))*(V(a4i7))))*cos((0+0*time))-(((V(a4r7))*(V(a4r7))-(V(a4i7))*(V(a4i7))))*sin((0+0*time))))))}
B12r7 a12r7 0 I={-(((-0.0638*(V(a12r7)))+(0*(V(a12i7)))+(-0.1344*(V(a12i6)-2*V(a12i7)+V(a12i8)))+(-0.01*((V(a4r7))*(V(a4r7))+(V(a4i7))*(V(a4i7))+(V(a8r7))*(V(a8r7))+(V(a8i7))*(V(a8i7))+(V(a12r7))*(V(a12r7))+(V(a12i7))*(V(a12i7)))*(V(a12r7)))+(0.075*((((V(a4r7))*(V(a8r7))-(V(a4i7))*(V(a8i7))))*cos((0+0*time))+(((V(a4r7))*(V(a8i7))+(V(a4i7))*(V(a8r7))))*sin((0+0*time))))))}
B12i7 a12i7 0 I={-(((-0.0638*(V(a12i7)))+(-0*(V(a12r7)))+(0.1344*(V(a12r6)-2*V(a12r7)+V(a12r8)))+(-0.01*((V(a4r7))*(V(a4r7))+(V(a4i7))*(V(a4i7))+(V(a8r7))*(V(a8r7))+(V(a8i7))*(V(a8i7))+(V(a12r7))*(V(a12r7))+(V(a12i7))*(V(a12i7)))*(V(a12i7)))+(0.075*((((V(a4r7))*(V(a8i7))+(V(a4i7))*(V(a8r7))))*cos((0+0*time))-(((V(a4r7))*(V(a8r7))-(V(a4i7))*(V(a8i7))))*sin((0+0*time))))))}
Idrive4_7 a4r7 0 PWL(0 0 11.52 -0.000143960859644 78.72 -0.000143960859644 96 0)
Idrive8_7 a8r7 0 PWL(0 0 11.52 -7.19804298222e-05 78.72 -7.19804298222e-05 96 0)

Ca4r8 a4r8 0 1 ic=0
Ra4r8 a4r8 0 1e12
Ca4i8 a4i8 0 1 ic=0
Ra4i8 a4i8 0 1e12
Ca8r8 a8r8 0 1 ic=0
Ra8r8 a8r8 0 1e12
Ca8i8 a8i8 0 1 ic=0
Ra8i8 a8i8 0 1e12
Ca12r8 a12r8 0 1 ic=0
Ra12r8 a12r8 0 1e12
Ca12i8 a12i8 0 1 ic=0
Ra12i8 a12i8 0 1e12
B4r8 a4r8 0 I={-(((-0.055*(V(a4r8)))+(-0.16*(V(a4i7)-2*V(a4i8)+V(a4i9)))+(-0.01*((V(a4r8))*(V(a4r8))+(V(a4i8))*(V(a4i8))+(V(a8r8))*(V(a8r8))+(V(a8i8))*(V(a8i8))+(V(a12r8))*(V(a12r8))+(V(a12i8))*(V(a12i8)))*(V(a4r8)))))}
B4i8 a4i8 0 I={-(((-0.055*(V(a4i8)))+(0.16*(V(a4r7)-2*V(a4r8)+V(a4r9)))+(-0.01*((V(a4r8))*(V(a4r8))+(V(a4i8))*(V(a4i8))+(V(a8r8))*(V(a8r8))+(V(a8i8))*(V(a8i8))+(V(a12r8))*(V(a12r8))+(V(a12i8))*(V(a12i8)))*(V(a4i8)))))}
B8r8 a8r8 0 I={-(((-0.0594*(V(a8r8)))+(0*(V(a8i8)))+(-0.1472*(V(a8i7)-2*V(a8i8)+V(a8i9)))+(-0.01*((V(a4r8))*(V(a4r8))+(V(a4i8))*(V(a4i8))+(V(a8r8))*(V(a8r8))+(V(a8i8))*(V(a8i8))+(V(a12r8))*(V(a12r8))+(V(a12i8))*(V(a12i8)))*(V(a8r8)))+(0.055*((((V(a4r8))*(V(a4r8))-(V(a4i8))*(V(a4i8))))*cos((0+0*time))+((2*(V(a4r8))*(V(a4i8))))*sin((0+0*time))))))}
B8i8 a8i8 0 I={-(((-0.0594*(V(a8i8)))+(-0*(V(a8r8)))+(0.1472*(V(a8r7)-2*V(a8r8)+V(a8r9)))+(-0.01*((V(a4r8))*(V(a4r8))+(V(a4i8))*(V(a4i8))+(V(a8r8))*(V(a8r8))+(V(a8i8))*(V(a8i8))+(V(a12r8))*(V(a12r8))+(V(a12i8))*(V(a12i8)))*(V(a8i8)))+(0.055*(((2*(V(a4r8))*(V(a4i8))))*cos((0+0*time))-(((V(a4r8))*(V(a4r8))-(V(a4i8))*(V(a4i8))))*sin((0+0*time))))))}
B12r8 a12r8 0 I={-(((-0.0638*(V(a12r8)))+(0*(V(a12i8)))+(-0.1344*(V(a12i7)-2*V(a12i8)+V(a12i9)))+(-0.01*((V(a4r8))*(V(a4r8))+(V(a4i8))*(V(a4i8))+(V(a8r8))*(V(a8r8))+(V(a8i8))*(V(a8i8))+(V(a12r8))*(V(a12r8))+(V(a12i8))*(V(a12i8)))*(V(a12r8)))+(0.075*((((V(a4r8))*(V(a8r8))-(V(a4i8))*(V(a8i8))))*cos((0+0*time))+(((V(a4r8))*(V(a8i8))+(V(a4i8))*(V(a8r8))))*sin((0+0*time))))))}
B12i8 a12i8 0 I={-(((-0.0638*(V(a12i8)))+(-0*(V(a12r8)))+(0.1344*(V(a12r7)-2*V(a12r8)+V(a12r9)))+(-0.01*((V(a4r8))*(V(a4r8))+(V(a4i8))*(V(a4i8))+(V(a8r8))*(V(a8r8))+(V(a8i8))*(V(a8i8))+(V(a12r8))*(V(a12r8))+(V(a12i8))*(V(a12i8)))*(V(a12i8)))+(0.075*((((V(a4r8))*(V(a8i8))+(V(a4i8))*(V(a8r8))))*cos((0+0*time))-(((V(a4r8))*(V(a8r8))-(V(a4i8))*(V(a8i8))))*sin((0+0*time))))))}
Idrive4_8 a4r8 0 PWL(0 0 11.52 -1.57096756241e-05 78.72 -1.57096756241e-05 96 0)
Idrive8_8 a8r8 0 PWL(0 0 11.52 -7.85483781205e-06 78.72 -7.85483781205e-06 96 0)

Ca4r9 a4r9 0 1 ic=0
Ra4r9 a4r9 0 1e12
Ca4i9 a4i9 0 1 ic=0
Ra4i9 a4i9 0 1e12
Ca8r9 a8r9 0 1 ic=0
Ra8r9 a8r9 0 1e12
Ca8i9 a8i9 0 1 ic=0
Ra8i9 a8i9 0 1e12
Ca12r9 a12r9 0 1 ic=0
Ra12r9 a12r9 0 1e12
Ca12i9 a12i9 0 1 ic=0
Ra12i9 a12i9 0 1e12
B4r9 a4r9 0 I={-(((-0.055*(V(a4r9)))+(-0.16*(V(a4i8)-2*V(a4i9)+V(a4i10)))+(-0.01*((V(a4r9))*(V(a4r9))+(V(a4i9))*(V(a4i9))+(V(a8r9))*(V(a8r9))+(V(a8i9))*(V(a8i9))+(V(a12r9))*(V(a12r9))+(V(a12i9))*(V(a12i9)))*(V(a4r9)))))}
B4i9 a4i9 0 I={-(((-0.055*(V(a4i9)))+(0.16*(V(a4r8)-2*V(a4r9)+V(a4r10)))+(-0.01*((V(a4r9))*(V(a4r9))+(V(a4i9))*(V(a4i9))+(V(a8r9))*(V(a8r9))+(V(a8i9))*(V(a8i9))+(V(a12r9))*(V(a12r9))+(V(a12i9))*(V(a12i9)))*(V(a4i9)))))}
B8r9 a8r9 0 I={-(((-0.0594*(V(a8r9)))+(0*(V(a8i9)))+(-0.1472*(V(a8i8)-2*V(a8i9)+V(a8i10)))+(-0.01*((V(a4r9))*(V(a4r9))+(V(a4i9))*(V(a4i9))+(V(a8r9))*(V(a8r9))+(V(a8i9))*(V(a8i9))+(V(a12r9))*(V(a12r9))+(V(a12i9))*(V(a12i9)))*(V(a8r9)))+(0.055*((((V(a4r9))*(V(a4r9))-(V(a4i9))*(V(a4i9))))*cos((0+0*time))+((2*(V(a4r9))*(V(a4i9))))*sin((0+0*time))))))}
B8i9 a8i9 0 I={-(((-0.0594*(V(a8i9)))+(-0*(V(a8r9)))+(0.1472*(V(a8r8)-2*V(a8r9)+V(a8r10)))+(-0.01*((V(a4r9))*(V(a4r9))+(V(a4i9))*(V(a4i9))+(V(a8r9))*(V(a8r9))+(V(a8i9))*(V(a8i9))+(V(a12r9))*(V(a12r9))+(V(a12i9))*(V(a12i9)))*(V(a8i9)))+(0.055*(((2*(V(a4r9))*(V(a4i9))))*cos((0+0*time))-(((V(a4r9))*(V(a4r9))-(V(a4i9))*(V(a4i9))))*sin((0+0*time))))))}
B12r9 a12r9 0 I={-(((-0.0638*(V(a12r9)))+(0*(V(a12i9)))+(-0.1344*(V(a12i8)-2*V(a12i9)+V(a12i10)))+(-0.01*((V(a4r9))*(V(a4r9))+(V(a4i9))*(V(a4i9))+(V(a8r9))*(V(a8r9))+(V(a8i9))*(V(a8i9))+(V(a12r9))*(V(a12r9))+(V(a12i9))*(V(a12i9)))*(V(a12r9)))+(0.075*((((V(a4r9))*(V(a8r9))-(V(a4i9))*(V(a8i9))))*cos((0+0*time))+(((V(a4r9))*(V(a8i9))+(V(a4i9))*(V(a8r9))))*sin((0+0*time))))))}
B12i9 a12i9 0 I={-(((-0.0638*(V(a12i9)))+(-0*(V(a12r9)))+(0.1344*(V(a12r8)-2*V(a12r9)+V(a12r10)))+(-0.01*((V(a4r9))*(V(a4r9))+(V(a4i9))*(V(a4i9))+(V(a8r9))*(V(a8r9))+(V(a8i9))*(V(a8i9))+(V(a12r9))*(V(a12r9))+(V(a12i9))*(V(a12i9)))*(V(a12i9)))+(0.075*((((V(a4r9))*(V(a8i9))+(V(a4i9))*(V(a8r9))))*cos((0+0*time))-(((V(a4r9))*(V(a8r9))-(V(a4i9))*(V(a8i9))))*sin((0+0*time))))))}
Idrive4_9 a4r9 0 PWL(0 0 11.52 -1.27588943821e-06 78.72 -1.27588943821e-06 96 0)
Idrive8_9 a8r9 0 PWL(0 0 11.52 -6.37944719106e-07 78.72 -6.37944719106e-07 96 0)

Ca4r10 a4r10 0 1 ic=0
Ra4r10 a4r10 0 1e12
Ca4i10 a4i10 0 1 ic=0
Ra4i10 a4i10 0 1e12
Ca8r10 a8r10 0 1 ic=0
Ra8r10 a8r10 0 1e12
Ca8i10 a8i10 0 1 ic=0
Ra8i10 a8i10 0 1e12
Ca12r10 a12r10 0 1 ic=0
Ra12r10 a12r10 0 1e12
Ca12i10 a12i10 0 1 ic=0
Ra12i10 a12i10 0 1e12
B4r10 a4r10 0 I={-(((-0.055*(V(a4r10)))+(-0.16*(V(a4i9)-2*V(a4i10)+V(a4i11)))+(-0.01*((V(a4r10))*(V(a4r10))+(V(a4i10))*(V(a4i10))+(V(a8r10))*(V(a8r10))+(V(a8i10))*(V(a8i10))+(V(a12r10))*(V(a12r10))+(V(a12i10))*(V(a12i10)))*(V(a4r10)))))}
B4i10 a4i10 0 I={-(((-0.055*(V(a4i10)))+(0.16*(V(a4r9)-2*V(a4r10)+V(a4r11)))+(-0.01*((V(a4r10))*(V(a4r10))+(V(a4i10))*(V(a4i10))+(V(a8r10))*(V(a8r10))+(V(a8i10))*(V(a8i10))+(V(a12r10))*(V(a12r10))+(V(a12i10))*(V(a12i10)))*(V(a4i10)))))}
B8r10 a8r10 0 I={-(((-0.0594*(V(a8r10)))+(0*(V(a8i10)))+(-0.1472*(V(a8i9)-2*V(a8i10)+V(a8i11)))+(-0.01*((V(a4r10))*(V(a4r10))+(V(a4i10))*(V(a4i10))+(V(a8r10))*(V(a8r10))+(V(a8i10))*(V(a8i10))+(V(a12r10))*(V(a12r10))+(V(a12i10))*(V(a12i10)))*(V(a8r10)))+(0.055*((((V(a4r10))*(V(a4r10))-(V(a4i10))*(V(a4i10))))*cos((0+0*time))+((2*(V(a4r10))*(V(a4i10))))*sin((0+0*time))))))}
B8i10 a8i10 0 I={-(((-0.0594*(V(a8i10)))+(-0*(V(a8r10)))+(0.1472*(V(a8r9)-2*V(a8r10)+V(a8r11)))+(-0.01*((V(a4r10))*(V(a4r10))+(V(a4i10))*(V(a4i10))+(V(a8r10))*(V(a8r10))+(V(a8i10))*(V(a8i10))+(V(a12r10))*(V(a12r10))+(V(a12i10))*(V(a12i10)))*(V(a8i10)))+(0.055*(((2*(V(a4r10))*(V(a4i10))))*cos((0+0*time))-(((V(a4r10))*(V(a4r10))-(V(a4i10))*(V(a4i10))))*sin((0+0*time))))))}
B12r10 a12r10 0 I={-(((-0.0638*(V(a12r10)))+(0*(V(a12i10)))+(-0.1344*(V(a12i9)-2*V(a12i10)+V(a12i11)))+(-0.01*((V(a4r10))*(V(a4r10))+(V(a4i10))*(V(a4i10))+(V(a8r10))*(V(a8r10))+(V(a8i10))*(V(a8i10))+(V(a12r10))*(V(a12r10))+(V(a12i10))*(V(a12i10)))*(V(a12r10)))+(0.075*((((V(a4r10))*(V(a8r10))-(V(a4i10))*(V(a8i10))))*cos((0+0*time))+(((V(a4r10))*(V(a8i10))+(V(a4i10))*(V(a8r10))))*sin((0+0*time))))))}
B12i10 a12i10 0 I={-(((-0.0638*(V(a12i10)))+(-0*(V(a12r10)))+(0.1344*(V(a12r9)-2*V(a12r10)+V(a12r11)))+(-0.01*((V(a4r10))*(V(a4r10))+(V(a4i10))*(V(a4i10))+(V(a8r10))*(V(a8r10))+(V(a8i10))*(V(a8i10))+(V(a12r10))*(V(a12r10))+(V(a12i10))*(V(a12i10)))*(V(a12i10)))+(0.075*((((V(a4r10))*(V(a8i10))+(V(a4i10))*(V(a8r10))))*cos((0+0*time))-(((V(a4r10))*(V(a8r10))-(V(a4i10))*(V(a8i10))))*sin((0+0*time))))))}
Idrive4_10 a4r10 0 PWL(0 0 11.52 -7.71226431266e-08 78.72 -7.71226431266e-08 96 0)
Idrive8_10 a8r10 0 PWL(0 0 11.52 -3.85613215633e-08 78.72 -3.85613215633e-08 96 0)

Ca4r11 a4r11 0 1 ic=0
Ra4r11 a4r11 0 1e12
Ca4i11 a4i11 0 1 ic=0
Ra4i11 a4i11 0 1e12
Ca8r11 a8r11 0 1 ic=0
Ra8r11 a8r11 0 1e12
Ca8i11 a8i11 0 1 ic=0
Ra8i11 a8i11 0 1e12
Ca12r11 a12r11 0 1 ic=0
Ra12r11 a12r11 0 1e12
Ca12i11 a12i11 0 1 ic=0
Ra12i11 a12i11 0 1e12
B4r11 a4r11 0 I={-(((-0.055*(V(a4r11)))+(-0.16*(V(a4i10)-2*V(a4i11)+V(a4i12)))+(-0.01*((V(a4r11))*(V(a4r11))+(V(a4i11))*(V(a4i11))+(V(a8r11))*(V(a8r11))+(V(a8i11))*(V(a8i11))+(V(a12r11))*(V(a12r11))+(V(a12i11))*(V(a12i11)))*(V(a4r11)))))}
B4i11 a4i11 0 I={-(((-0.055*(V(a4i11)))+(0.16*(V(a4r10)-2*V(a4r11)+V(a4r12)))+(-0.01*((V(a4r11))*(V(a4r11))+(V(a4i11))*(V(a4i11))+(V(a8r11))*(V(a8r11))+(V(a8i11))*(V(a8i11))+(V(a12r11))*(V(a12r11))+(V(a12i11))*(V(a12i11)))*(V(a4i11)))))}
B8r11 a8r11 0 I={-(((-0.0594*(V(a8r11)))+(0*(V(a8i11)))+(-0.1472*(V(a8i10)-2*V(a8i11)+V(a8i12)))+(-0.01*((V(a4r11))*(V(a4r11))+(V(a4i11))*(V(a4i11))+(V(a8r11))*(V(a8r11))+(V(a8i11))*(V(a8i11))+(V(a12r11))*(V(a12r11))+(V(a12i11))*(V(a12i11)))*(V(a8r11)))+(0.055*((((V(a4r11))*(V(a4r11))-(V(a4i11))*(V(a4i11))))*cos((0+0*time))+((2*(V(a4r11))*(V(a4i11))))*sin((0+0*time))))))}
B8i11 a8i11 0 I={-(((-0.0594*(V(a8i11)))+(-0*(V(a8r11)))+(0.1472*(V(a8r10)-2*V(a8r11)+V(a8r12)))+(-0.01*((V(a4r11))*(V(a4r11))+(V(a4i11))*(V(a4i11))+(V(a8r11))*(V(a8r11))+(V(a8i11))*(V(a8i11))+(V(a12r11))*(V(a12r11))+(V(a12i11))*(V(a12i11)))*(V(a8i11)))+(0.055*(((2*(V(a4r11))*(V(a4i11))))*cos((0+0*time))-(((V(a4r11))*(V(a4r11))-(V(a4i11))*(V(a4i11))))*sin((0+0*time))))))}
B12r11 a12r11 0 I={-(((-0.0638*(V(a12r11)))+(0*(V(a12i11)))+(-0.1344*(V(a12i10)-2*V(a12i11)+V(a12i12)))+(-0.01*((V(a4r11))*(V(a4r11))+(V(a4i11))*(V(a4i11))+(V(a8r11))*(V(a8r11))+(V(a8i11))*(V(a8i11))+(V(a12r11))*(V(a12r11))+(V(a12i11))*(V(a12i11)))*(V(a12r11)))+(0.075*((((V(a4r11))*(V(a8r11))-(V(a4i11))*(V(a8i11))))*cos((0+0*time))+(((V(a4r11))*(V(a8i11))+(V(a4i11))*(V(a8r11))))*sin((0+0*time))))))}
B12i11 a12i11 0 I={-(((-0.0638*(V(a12i11)))+(-0*(V(a12r11)))+(0.1344*(V(a12r10)-2*V(a12r11)+V(a12r12)))+(-0.01*((V(a4r11))*(V(a4r11))+(V(a4i11))*(V(a4i11))+(V(a8r11))*(V(a8r11))+(V(a8i11))*(V(a8i11))+(V(a12r11))*(V(a12r11))+(V(a12i11))*(V(a12i11)))*(V(a12i11)))+(0.075*((((V(a4r11))*(V(a8i11))+(V(a4i11))*(V(a8r11))))*cos((0+0*time))-(((V(a4r11))*(V(a8r11))-(V(a4i11))*(V(a8i11))))*sin((0+0*time))))))}
Idrive4_11 a4r11 0 PWL(0 0 11.52 -3.46955523789e-09 78.72 -3.46955523789e-09 96 0)
Idrive8_11 a8r11 0 PWL(0 0 11.52 -1.73477761894e-09 78.72 -1.73477761894e-09 96 0)

Ca4r12 a4r12 0 1 ic=0
Ra4r12 a4r12 0 1e12
Ca4i12 a4i12 0 1 ic=0
Ra4i12 a4i12 0 1e12
Ca8r12 a8r12 0 1 ic=0
Ra8r12 a8r12 0 1e12
Ca8i12 a8i12 0 1 ic=0
Ra8i12 a8i12 0 1e12
Ca12r12 a12r12 0 1 ic=0
Ra12r12 a12r12 0 1e12
Ca12i12 a12i12 0 1 ic=0
Ra12i12 a12i12 0 1e12
B4r12 a4r12 0 I={-(((-0.055*(V(a4r12)))+(-0.16*(V(a4i11)-2*V(a4i12)+V(a4i13)))+(-0.01*((V(a4r12))*(V(a4r12))+(V(a4i12))*(V(a4i12))+(V(a8r12))*(V(a8r12))+(V(a8i12))*(V(a8i12))+(V(a12r12))*(V(a12r12))+(V(a12i12))*(V(a12i12)))*(V(a4r12)))))}
B4i12 a4i12 0 I={-(((-0.055*(V(a4i12)))+(0.16*(V(a4r11)-2*V(a4r12)+V(a4r13)))+(-0.01*((V(a4r12))*(V(a4r12))+(V(a4i12))*(V(a4i12))+(V(a8r12))*(V(a8r12))+(V(a8i12))*(V(a8i12))+(V(a12r12))*(V(a12r12))+(V(a12i12))*(V(a12i12)))*(V(a4i12)))))}
B8r12 a8r12 0 I={-(((-0.0594*(V(a8r12)))+(0*(V(a8i12)))+(-0.1472*(V(a8i11)-2*V(a8i12)+V(a8i13)))+(-0.01*((V(a4r12))*(V(a4r12))+(V(a4i12))*(V(a4i12))+(V(a8r12))*(V(a8r12))+(V(a8i12))*(V(a8i12))+(V(a12r12))*(V(a12r12))+(V(a12i12))*(V(a12i12)))*(V(a8r12)))+(0.055*((((V(a4r12))*(V(a4r12))-(V(a4i12))*(V(a4i12))))*cos((0+0*time))+((2*(V(a4r12))*(V(a4i12))))*sin((0+0*time))))))}
B8i12 a8i12 0 I={-(((-0.0594*(V(a8i12)))+(-0*(V(a8r12)))+(0.1472*(V(a8r11)-2*V(a8r12)+V(a8r13)))+(-0.01*((V(a4r12))*(V(a4r12))+(V(a4i12))*(V(a4i12))+(V(a8r12))*(V(a8r12))+(V(a8i12))*(V(a8i12))+(V(a12r12))*(V(a12r12))+(V(a12i12))*(V(a12i12)))*(V(a8i12)))+(0.055*(((2*(V(a4r12))*(V(a4i12))))*cos((0+0*time))-(((V(a4r12))*(V(a4r12))-(V(a4i12))*(V(a4i12))))*sin((0+0*time))))))}
B12r12 a12r12 0 I={-(((-0.0638*(V(a12r12)))+(0*(V(a12i12)))+(-0.1344*(V(a12i11)-2*V(a12i12)+V(a12i13)))+(-0.01*((V(a4r12))*(V(a4r12))+(V(a4i12))*(V(a4i12))+(V(a8r12))*(V(a8r12))+(V(a8i12))*(V(a8i12))+(V(a12r12))*(V(a12r12))+(V(a12i12))*(V(a12i12)))*(V(a12r12)))+(0.075*((((V(a4r12))*(V(a8r12))-(V(a4i12))*(V(a8i12))))*cos((0+0*time))+(((V(a4r12))*(V(a8i12))+(V(a4i12))*(V(a8r12))))*sin((0+0*time))))))}
B12i12 a12i12 0 I={-(((-0.0638*(V(a12i12)))+(-0*(V(a12r12)))+(0.1344*(V(a12r11)-2*V(a12r12)+V(a12r13)))+(-0.01*((V(a4r12))*(V(a4r12))+(V(a4i12))*(V(a4i12))+(V(a8r12))*(V(a8r12))+(V(a8i12))*(V(a8i12))+(V(a12r12))*(V(a12r12))+(V(a12i12))*(V(a12i12)))*(V(a12i12)))+(0.075*((((V(a4r12))*(V(a8i12))+(V(a4i12))*(V(a8r12))))*cos((0+0*time))-(((V(a4r12))*(V(a8r12))-(V(a4i12))*(V(a8i12))))*sin((0+0*time))))))}
Idrive4_12 a4r12 0 PWL(0 0 11.52 -1.16168597284e-10 78.72 -1.16168597284e-10 96 0)
Idrive8_12 a8r12 0 PWL(0 0 11.52 -5.80842986422e-11 78.72 -5.80842986422e-11 96 0)

Ca4r13 a4r13 0 1 ic=0
Ra4r13 a4r13 0 1e12
Ca4i13 a4i13 0 1 ic=0
Ra4i13 a4i13 0 1e12
Ca8r13 a8r13 0 1 ic=0
Ra8r13 a8r13 0 1e12
Ca8i13 a8i13 0 1 ic=0
Ra8i13 a8i13 0 1e12
Ca12r13 a12r13 0 1 ic=0
Ra12r13 a12r13 0 1e12
Ca12i13 a12i13 0 1 ic=0
Ra12i13 a12i13 0 1e12
B4r13 a4r13 0 I={-(((-0.055*(V(a4r13)))+(-0.16*(V(a4i12)-2*V(a4i13)+V(a4i14)))+(-0.01*((V(a4r13))*(V(a4r13))+(V(a4i13))*(V(a4i13))+(V(a8r13))*(V(a8r13))+(V(a8i13))*(V(a8i13))+(V(a12r13))*(V(a12r13))+(V(a12i13))*(V(a12i13)))*(V(a4r13)))))}
B4i13 a4i13 0 I={-(((-0.055*(V(a4i13)))+(0.16*(V(a4r12)-2*V(a4r13)+V(a4r14)))+(-0.01*((V(a4r13))*(V(a4r13))+(V(a4i13))*(V(a4i13))+(V(a8r13))*(V(a8r13))+(V(a8i13))*(V(a8i13))+(V(a12r13))*(V(a12r13))+(V(a12i13))*(V(a12i13)))*(V(a4i13)))))}
B8r13 a8r13 0 I={-(((-0.0594*(V(a8r13)))+(0*(V(a8i13)))+(-0.1472*(V(a8i12)-2*V(a8i13)+V(a8i14)))+(-0.01*((V(a4r13))*(V(a4r13))+(V(a4i13))*(V(a4i13))+(V(a8r13))*(V(a8r13))+(V(a8i13))*(V(a8i13))+(V(a12r13))*(V(a12r13))+(V(a12i13))*(V(a12i13)))*(V(a8r13)))+(0.055*((((V(a4r13))*(V(a4r13))-(V(a4i13))*(V(a4i13))))*cos((0+0*time))+((2*(V(a4r13))*(V(a4i13))))*sin((0+0*time))))))}
B8i13 a8i13 0 I={-(((-0.0594*(V(a8i13)))+(-0*(V(a8r13)))+(0.1472*(V(a8r12)-2*V(a8r13)+V(a8r14)))+(-0.01*((V(a4r13))*(V(a4r13))+(V(a4i13))*(V(a4i13))+(V(a8r13))*(V(a8r13))+(V(a8i13))*(V(a8i13))+(V(a12r13))*(V(a12r13))+(V(a12i13))*(V(a12i13)))*(V(a8i13)))+(0.055*(((2*(V(a4r13))*(V(a4i13))))*cos((0+0*time))-(((V(a4r13))*(V(a4r13))-(V(a4i13))*(V(a4i13))))*sin((0+0*time))))))}
B12r13 a12r13 0 I={-(((-0.0638*(V(a12r13)))+(0*(V(a12i13)))+(-0.1344*(V(a12i12)-2*V(a12i13)+V(a12i14)))+(-0.01*((V(a4r13))*(V(a4r13))+(V(a4i13))*(V(a4i13))+(V(a8r13))*(V(a8r13))+(V(a8i13))*(V(a8i13))+(V(a12r13))*(V(a12r13))+(V(a12i13))*(V(a12i13)))*(V(a12r13)))+(0.075*((((V(a4r13))*(V(a8r13))-(V(a4i13))*(V(a8i13))))*cos((0+0*time))+(((V(a4r13))*(V(a8i13))+(V(a4i13))*(V(a8r13))))*sin((0+0*time))))))}
B12i13 a12i13 0 I={-(((-0.0638*(V(a12i13)))+(-0*(V(a12r13)))+(0.1344*(V(a12r12)-2*V(a12r13)+V(a12r14)))+(-0.01*((V(a4r13))*(V(a4r13))+(V(a4i13))*(V(a4i13))+(V(a8r13))*(V(a8r13))+(V(a8i13))*(V(a8i13))+(V(a12r13))*(V(a12r13))+(V(a12i13))*(V(a12i13)))*(V(a12i13)))+(0.075*((((V(a4r13))*(V(a8i13))+(V(a4i13))*(V(a8r13))))*cos((0+0*time))-(((V(a4r13))*(V(a8r13))-(V(a4i13))*(V(a8i13))))*sin((0+0*time))))))}
Idrive4_13 a4r13 0 PWL(0 0 11.52 -2.89485438306e-12 78.72 -2.89485438306e-12 96 0)
Idrive8_13 a8r13 0 PWL(0 0 11.52 -1.44742719153e-12 78.72 -1.44742719153e-12 96 0)

Ca4r14 a4r14 0 1 ic=0
Ra4r14 a4r14 0 1e12
Ca4i14 a4i14 0 1 ic=0
Ra4i14 a4i14 0 1e12
Ca8r14 a8r14 0 1 ic=0
Ra8r14 a8r14 0 1e12
Ca8i14 a8i14 0 1 ic=0
Ra8i14 a8i14 0 1e12
Ca12r14 a12r14 0 1 ic=0
Ra12r14 a12r14 0 1e12
Ca12i14 a12i14 0 1 ic=0
Ra12i14 a12i14 0 1e12
B4r14 a4r14 0 I={-(((-0.055*(V(a4r14)))+(-0.16*(V(a4i13)-2*V(a4i14)+V(a4i15)))+(-0.01*((V(a4r14))*(V(a4r14))+(V(a4i14))*(V(a4i14))+(V(a8r14))*(V(a8r14))+(V(a8i14))*(V(a8i14))+(V(a12r14))*(V(a12r14))+(V(a12i14))*(V(a12i14)))*(V(a4r14)))))}
B4i14 a4i14 0 I={-(((-0.055*(V(a4i14)))+(0.16*(V(a4r13)-2*V(a4r14)+V(a4r15)))+(-0.01*((V(a4r14))*(V(a4r14))+(V(a4i14))*(V(a4i14))+(V(a8r14))*(V(a8r14))+(V(a8i14))*(V(a8i14))+(V(a12r14))*(V(a12r14))+(V(a12i14))*(V(a12i14)))*(V(a4i14)))))}
B8r14 a8r14 0 I={-(((-0.0594*(V(a8r14)))+(0*(V(a8i14)))+(-0.1472*(V(a8i13)-2*V(a8i14)+V(a8i15)))+(-0.01*((V(a4r14))*(V(a4r14))+(V(a4i14))*(V(a4i14))+(V(a8r14))*(V(a8r14))+(V(a8i14))*(V(a8i14))+(V(a12r14))*(V(a12r14))+(V(a12i14))*(V(a12i14)))*(V(a8r14)))+(0.055*((((V(a4r14))*(V(a4r14))-(V(a4i14))*(V(a4i14))))*cos((0+0*time))+((2*(V(a4r14))*(V(a4i14))))*sin((0+0*time))))))}
B8i14 a8i14 0 I={-(((-0.0594*(V(a8i14)))+(-0*(V(a8r14)))+(0.1472*(V(a8r13)-2*V(a8r14)+V(a8r15)))+(-0.01*((V(a4r14))*(V(a4r14))+(V(a4i14))*(V(a4i14))+(V(a8r14))*(V(a8r14))+(V(a8i14))*(V(a8i14))+(V(a12r14))*(V(a12r14))+(V(a12i14))*(V(a12i14)))*(V(a8i14)))+(0.055*(((2*(V(a4r14))*(V(a4i14))))*cos((0+0*time))-(((V(a4r14))*(V(a4r14))-(V(a4i14))*(V(a4i14))))*sin((0+0*time))))))}
B12r14 a12r14 0 I={-(((-0.0638*(V(a12r14)))+(0*(V(a12i14)))+(-0.1344*(V(a12i13)-2*V(a12i14)+V(a12i15)))+(-0.01*((V(a4r14))*(V(a4r14))+(V(a4i14))*(V(a4i14))+(V(a8r14))*(V(a8r14))+(V(a8i14))*(V(a8i14))+(V(a12r14))*(V(a12r14))+(V(a12i14))*(V(a12i14)))*(V(a12r14)))+(0.075*((((V(a4r14))*(V(a8r14))-(V(a4i14))*(V(a8i14))))*cos((0+0*time))+(((V(a4r14))*(V(a8i14))+(V(a4i14))*(V(a8r14))))*sin((0+0*time))))))}
B12i14 a12i14 0 I={-(((-0.0638*(V(a12i14)))+(-0*(V(a12r14)))+(0.1344*(V(a12r13)-2*V(a12r14)+V(a12r15)))+(-0.01*((V(a4r14))*(V(a4r14))+(V(a4i14))*(V(a4i14))+(V(a8r14))*(V(a8r14))+(V(a8i14))*(V(a8i14))+(V(a12r14))*(V(a12r14))+(V(a12i14))*(V(a12i14)))*(V(a12i14)))+(0.075*((((V(a4r14))*(V(a8i14))+(V(a4i14))*(V(a8r14))))*cos((0+0*time))-(((V(a4r14))*(V(a8r14))-(V(a4i14))*(V(a8i14))))*sin((0+0*time))))))}
Idrive4_14 a4r14 0 PWL(0 0 11.52 -5.36892995829e-14 78.72 -5.36892995829e-14 96 0)
Idrive8_14 a8r14 0 PWL(0 0 11.52 -2.68446497915e-14 78.72 -2.68446497915e-14 96 0)

Ca4r15 a4r15 0 1 ic=0
Ra4r15 a4r15 0 1e12
Ca4i15 a4i15 0 1 ic=0
Ra4i15 a4i15 0 1e12
Ca8r15 a8r15 0 1 ic=0
Ra8r15 a8r15 0 1e12
Ca8i15 a8i15 0 1 ic=0
Ra8i15 a8i15 0 1e12
Ca12r15 a12r15 0 1 ic=0
Ra12r15 a12r15 0 1e12
Ca12i15 a12i15 0 1 ic=0
Ra12i15 a12i15 0 1e12
B4r15 a4r15 0 I={-(((-0.055*(V(a4r15)))+(-0.16*(V(a4i14)-2*V(a4i15)+V(a4i16)))+(-0.01*((V(a4r15))*(V(a4r15))+(V(a4i15))*(V(a4i15))+(V(a8r15))*(V(a8r15))+(V(a8i15))*(V(a8i15))+(V(a12r15))*(V(a12r15))+(V(a12i15))*(V(a12i15)))*(V(a4r15)))))}
B4i15 a4i15 0 I={-(((-0.055*(V(a4i15)))+(0.16*(V(a4r14)-2*V(a4r15)+V(a4r16)))+(-0.01*((V(a4r15))*(V(a4r15))+(V(a4i15))*(V(a4i15))+(V(a8r15))*(V(a8r15))+(V(a8i15))*(V(a8i15))+(V(a12r15))*(V(a12r15))+(V(a12i15))*(V(a12i15)))*(V(a4i15)))))}
B8r15 a8r15 0 I={-(((-0.0594*(V(a8r15)))+(0*(V(a8i15)))+(-0.1472*(V(a8i14)-2*V(a8i15)+V(a8i16)))+(-0.01*((V(a4r15))*(V(a4r15))+(V(a4i15))*(V(a4i15))+(V(a8r15))*(V(a8r15))+(V(a8i15))*(V(a8i15))+(V(a12r15))*(V(a12r15))+(V(a12i15))*(V(a12i15)))*(V(a8r15)))+(0.055*((((V(a4r15))*(V(a4r15))-(V(a4i15))*(V(a4i15))))*cos((0+0*time))+((2*(V(a4r15))*(V(a4i15))))*sin((0+0*time))))))}
B8i15 a8i15 0 I={-(((-0.0594*(V(a8i15)))+(-0*(V(a8r15)))+(0.1472*(V(a8r14)-2*V(a8r15)+V(a8r16)))+(-0.01*((V(a4r15))*(V(a4r15))+(V(a4i15))*(V(a4i15))+(V(a8r15))*(V(a8r15))+(V(a8i15))*(V(a8i15))+(V(a12r15))*(V(a12r15))+(V(a12i15))*(V(a12i15)))*(V(a8i15)))+(0.055*(((2*(V(a4r15))*(V(a4i15))))*cos((0+0*time))-(((V(a4r15))*(V(a4r15))-(V(a4i15))*(V(a4i15))))*sin((0+0*time))))))}
B12r15 a12r15 0 I={-(((-0.0638*(V(a12r15)))+(0*(V(a12i15)))+(-0.1344*(V(a12i14)-2*V(a12i15)+V(a12i16)))+(-0.01*((V(a4r15))*(V(a4r15))+(V(a4i15))*(V(a4i15))+(V(a8r15))*(V(a8r15))+(V(a8i15))*(V(a8i15))+(V(a12r15))*(V(a12r15))+(V(a12i15))*(V(a12i15)))*(V(a12r15)))+(0.075*((((V(a4r15))*(V(a8r15))-(V(a4i15))*(V(a8i15))))*cos((0+0*time))+(((V(a4r15))*(V(a8i15))+(V(a4i15))*(V(a8r15))))*sin((0+0*time))))))}
B12i15 a12i15 0 I={-(((-0.0638*(V(a12i15)))+(-0*(V(a12r15)))+(0.1344*(V(a12r14)-2*V(a12r15)+V(a12r16)))+(-0.01*((V(a4r15))*(V(a4r15))+(V(a4i15))*(V(a4i15))+(V(a8r15))*(V(a8r15))+(V(a8i15))*(V(a8i15))+(V(a12r15))*(V(a12r15))+(V(a12i15))*(V(a12i15)))*(V(a12i15)))+(0.075*((((V(a4r15))*(V(a8i15))+(V(a4i15))*(V(a8r15))))*cos((0+0*time))-(((V(a4r15))*(V(a8r15))-(V(a4i15))*(V(a8i15))))*sin((0+0*time))))))}

Ca4r16 a4r16 0 1 ic=0
Ra4r16 a4r16 0 1e12
Ca4i16 a4i16 0 1 ic=0
Ra4i16 a4i16 0 1e12
Ca8r16 a8r16 0 1 ic=0
Ra8r16 a8r16 0 1e12
Ca8i16 a8i16 0 1 ic=0
Ra8i16 a8i16 0 1e12
Ca12r16 a12r16 0 1 ic=0
Ra12r16 a12r16 0 1e12
Ca12i16 a12i16 0 1 ic=0
Ra12i16 a12i16 0 1e12
B4r16 a4r16 0 I={-(((-0.055*(V(a4r16)))+(-0.16*(V(a4i15)-2*V(a4i16)+V(a4i17)))+(-0.01*((V(a4r16))*(V(a4r16))+(V(a4i16))*(V(a4i16))+(V(a8r16))*(V(a8r16))+(V(a8i16))*(V(a8i16))+(V(a12r16))*(V(a12r16))+(V(a12i16))*(V(a12i16)))*(V(a4r16)))))}
B4i16 a4i16 0 I={-(((-0.055*(V(a4i16)))+(0.16*(V(a4r15)-2*V(a4r16)+V(a4r17)))+(-0.01*((V(a4r16))*(V(a4r16))+(V(a4i16))*(V(a4i16))+(V(a8r16))*(V(a8r16))+(V(a8i16))*(V(a8i16))+(V(a12r16))*(V(a12r16))+(V(a12i16))*(V(a12i16)))*(V(a4i16)))))}
B8r16 a8r16 0 I={-(((-0.0594*(V(a8r16)))+(0*(V(a8i16)))+(-0.1472*(V(a8i15)-2*V(a8i16)+V(a8i17)))+(-0.01*((V(a4r16))*(V(a4r16))+(V(a4i16))*(V(a4i16))+(V(a8r16))*(V(a8r16))+(V(a8i16))*(V(a8i16))+(V(a12r16))*(V(a12r16))+(V(a12i16))*(V(a12i16)))*(V(a8r16)))+(0.055*((((V(a4r16))*(V(a4r16))-(V(a4i16))*(V(a4i16))))*cos((0+0*time))+((2*(V(a4r16))*(V(a4i16))))*sin((0+0*time))))))}
B8i16 a8i16 0 I={-(((-0.0594*(V(a8i16)))+(-0*(V(a8r16)))+(0.1472*(V(a8r15)-2*V(a8r16)+V(a8r17)))+(-0.01*((V(a4r16))*(V(a4r16))+(V(a4i16))*(V(a4i16))+(V(a8r16))*(V(a8r16))+(V(a8i16))*(V(a8i16))+(V(a12r16))*(V(a12r16))+(V(a12i16))*(V(a12i16)))*(V(a8i16)))+(0.055*(((2*(V(a4r16))*(V(a4i16))))*cos((0+0*time))-(((V(a4r16))*(V(a4r16))-(V(a4i16))*(V(a4i16))))*sin((0+0*time))))))}
B12r16 a12r16 0 I={-(((-0.0638*(V(a12r16)))+(0*(V(a12i16)))+(-0.1344*(V(a12i15)-2*V(a12i16)+V(a12i17)))+(-0.01*((V(a4r16))*(V(a4r16))+(V(a4i16))*(V(a4i16))+(V(a8r16))*(V(a8r16))+(V(a8i16))*(V(a8i16))+(V(a12r16))*(V(a12r16))+(V(a12i16))*(V(a12i16)))*(V(a12r16)))+(0.075*((((V(a4r16))*(V(a8r16))-(V(a4i16))*(V(a8i16))))*cos((0+0*time))+(((V(a4r16))*(V(a8i16))+(V(a4i16))*(V(a8r16))))*sin((0+0*time))))))}
B12i16 a12i16 0 I={-(((-0.0638*(V(a12i16)))+(-0*(V(a12r16)))+(0.1344*(V(a12r15)-2*V(a12r16)+V(a12r17)))+(-0.01*((V(a4r16))*(V(a4r16))+(V(a4i16))*(V(a4i16))+(V(a8r16))*(V(a8r16))+(V(a8i16))*(V(a8i16))+(V(a12r16))*(V(a12r16))+(V(a12i16))*(V(a12i16)))*(V(a12i16)))+(0.075*((((V(a4r16))*(V(a8i16))+(V(a4i16))*(V(a8r16))))*cos((0+0*time))-(((V(a4r16))*(V(a8r16))-(V(a4i16))*(V(a8i16))))*sin((0+0*time))))))}

Ca4r17 a4r17 0 1 ic=0
Ra4r17 a4r17 0 1e12
Ca4i17 a4i17 0 1 ic=0
Ra4i17 a4i17 0 1e12
Ca8r17 a8r17 0 1 ic=0
Ra8r17 a8r17 0 1e12
Ca8i17 a8i17 0 1 ic=0
Ra8i17 a8i17 0 1e12
Ca12r17 a12r17 0 1 ic=0
Ra12r17 a12r17 0 1e12
Ca12i17 a12i17 0 1 ic=0
Ra12i17 a12i17 0 1e12
B4r17 a4r17 0 I={-(((-0.055*(V(a4r17)))+(-0.16*(V(a4i16)-2*V(a4i17)+V(a4i18)))+(-0.01*((V(a4r17))*(V(a4r17))+(V(a4i17))*(V(a4i17))+(V(a8r17))*(V(a8r17))+(V(a8i17))*(V(a8i17))+(V(a12r17))*(V(a12r17))+(V(a12i17))*(V(a12i17)))*(V(a4r17)))))}
B4i17 a4i17 0 I={-(((-0.055*(V(a4i17)))+(0.16*(V(a4r16)-2*V(a4r17)+V(a4r18)))+(-0.01*((V(a4r17))*(V(a4r17))+(V(a4i17))*(V(a4i17))+(V(a8r17))*(V(a8r17))+(V(a8i17))*(V(a8i17))+(V(a12r17))*(V(a12r17))+(V(a12i17))*(V(a12i17)))*(V(a4i17)))))}
B8r17 a8r17 0 I={-(((-0.0594*(V(a8r17)))+(0*(V(a8i17)))+(-0.1472*(V(a8i16)-2*V(a8i17)+V(a8i18)))+(-0.01*((V(a4r17))*(V(a4r17))+(V(a4i17))*(V(a4i17))+(V(a8r17))*(V(a8r17))+(V(a8i17))*(V(a8i17))+(V(a12r17))*(V(a12r17))+(V(a12i17))*(V(a12i17)))*(V(a8r17)))+(0.055*((((V(a4r17))*(V(a4r17))-(V(a4i17))*(V(a4i17))))*cos((0+0*time))+((2*(V(a4r17))*(V(a4i17))))*sin((0+0*time))))))}
B8i17 a8i17 0 I={-(((-0.0594*(V(a8i17)))+(-0*(V(a8r17)))+(0.1472*(V(a8r16)-2*V(a8r17)+V(a8r18)))+(-0.01*((V(a4r17))*(V(a4r17))+(V(a4i17))*(V(a4i17))+(V(a8r17))*(V(a8r17))+(V(a8i17))*(V(a8i17))+(V(a12r17))*(V(a12r17))+(V(a12i17))*(V(a12i17)))*(V(a8i17)))+(0.055*(((2*(V(a4r17))*(V(a4i17))))*cos((0+0*time))-(((V(a4r17))*(V(a4r17))-(V(a4i17))*(V(a4i17))))*sin((0+0*time))))))}
B12r17 a12r17 0 I={-(((-0.0638*(V(a12r17)))+(0*(V(a12i17)))+(-0.1344*(V(a12i16)-2*V(a12i17)+V(a12i18)))+(-0.01*((V(a4r17))*(V(a4r17))+(V(a4i17))*(V(a4i17))+(V(a8r17))*(V(a8r17))+(V(a8i17))*(V(a8i17))+(V(a12r17))*(V(a12r17))+(V(a12i17))*(V(a12i17)))*(V(a12r17)))+(0.075*((((V(a4r17))*(V(a8r17))-(V(a4i17))*(V(a8i17))))*cos((0+0*time))+(((V(a4r17))*(V(a8i17))+(V(a4i17))*(V(a8r17))))*sin((0+0*time))))))}
B12i17 a12i17 0 I={-(((-0.0638*(V(a12i17)))+(-0*(V(a12r17)))+(0.1344*(V(a12r16)-2*V(a12r17)+V(a12r18)))+(-0.01*((V(a4r17))*(V(a4r17))+(V(a4i17))*(V(a4i17))+(V(a8r17))*(V(a8r17))+(V(a8i17))*(V(a8i17))+(V(a12r17))*(V(a12r17))+(V(a12i17))*(V(a12i17)))*(V(a12i17)))+(0.075*((((V(a4r17))*(V(a8i17))+(V(a4i17))*(V(a8r17))))*cos((0+0*time))-(((V(a4r17))*(V(a8r17))-(V(a4i17))*(V(a8i17))))*sin((0+0*time))))))}

Ca4r18 a4r18 0 1 ic=0
Ra4r18 a4r18 0 1e12
Ca4i18 a4i18 0 1 ic=0
Ra4i18 a4i18 0 1e12
Ca8r18 a8r18 0 1 ic=0
Ra8r18 a8r18 0 1e12
Ca8i18 a8i18 0 1 ic=0
Ra8i18 a8i18 0 1e12
Ca12r18 a12r18 0 1 ic=0
Ra12r18 a12r18 0 1e12
Ca12i18 a12i18 0 1 ic=0
Ra12i18 a12i18 0 1e12
B4r18 a4r18 0 I={-(((-0.055*(V(a4r18)))+(-0.16*(V(a4i17)-2*V(a4i18)+V(a4i19)))+(-0.01*((V(a4r18))*(V(a4r18))+(V(a4i18))*(V(a4i18))+(V(a8r18))*(V(a8r18))+(V(a8i18))*(V(a8i18))+(V(a12r18))*(V(a12r18))+(V(a12i18))*(V(a12i18)))*(V(a4r18)))))}
B4i18 a4i18 0 I={-(((-0.055*(V(a4i18)))+(0.16*(V(a4r17)-2*V(a4r18)+V(a4r19)))+(-0.01*((V(a4r18))*(V(a4r18))+(V(a4i18))*(V(a4i18))+(V(a8r18))*(V(a8r18))+(V(a8i18))*(V(a8i18))+(V(a12r18))*(V(a12r18))+(V(a12i18))*(V(a12i18)))*(V(a4i18)))))}
B8r18 a8r18 0 I={-(((-0.0594*(V(a8r18)))+(0*(V(a8i18)))+(-0.1472*(V(a8i17)-2*V(a8i18)+V(a8i19)))+(-0.01*((V(a4r18))*(V(a4r18))+(V(a4i18))*(V(a4i18))+(V(a8r18))*(V(a8r18))+(V(a8i18))*(V(a8i18))+(V(a12r18))*(V(a12r18))+(V(a12i18))*(V(a12i18)))*(V(a8r18)))+(0.055*((((V(a4r18))*(V(a4r18))-(V(a4i18))*(V(a4i18))))*cos((0+0*time))+((2*(V(a4r18))*(V(a4i18))))*sin((0+0*time))))))}
B8i18 a8i18 0 I={-(((-0.0594*(V(a8i18)))+(-0*(V(a8r18)))+(0.1472*(V(a8r17)-2*V(a8r18)+V(a8r19)))+(-0.01*((V(a4r18))*(V(a4r18))+(V(a4i18))*(V(a4i18))+(V(a8r18))*(V(a8r18))+(V(a8i18))*(V(a8i18))+(V(a12r18))*(V(a12r18))+(V(a12i18))*(V(a12i18)))*(V(a8i18)))+(0.055*(((2*(V(a4r18))*(V(a4i18))))*cos((0+0*time))-(((V(a4r18))*(V(a4r18))-(V(a4i18))*(V(a4i18))))*sin((0+0*time))))))}
B12r18 a12r18 0 I={-(((-0.0638*(V(a12r18)))+(0*(V(a12i18)))+(-0.1344*(V(a12i17)-2*V(a12i18)+V(a12i19)))+(-0.01*((V(a4r18))*(V(a4r18))+(V(a4i18))*(V(a4i18))+(V(a8r18))*(V(a8r18))+(V(a8i18))*(V(a8i18))+(V(a12r18))*(V(a12r18))+(V(a12i18))*(V(a12i18)))*(V(a12r18)))+(0.075*((((V(a4r18))*(V(a8r18))-(V(a4i18))*(V(a8i18))))*cos((0+0*time))+(((V(a4r18))*(V(a8i18))+(V(a4i18))*(V(a8r18))))*sin((0+0*time))))))}
B12i18 a12i18 0 I={-(((-0.0638*(V(a12i18)))+(-0*(V(a12r18)))+(0.1344*(V(a12r17)-2*V(a12r18)+V(a12r19)))+(-0.01*((V(a4r18))*(V(a4r18))+(V(a4i18))*(V(a4i18))+(V(a8r18))*(V(a8r18))+(V(a8i18))*(V(a8i18))+(V(a12r18))*(V(a12r18))+(V(a12i18))*(V(a12i18)))*(V(a12i18)))+(0.075*((((V(a4r18))*(V(a8i18))+(V(a4i18))*(V(a8r18))))*cos((0+0*time))-(((V(a4r18))*(V(a8r18))-(V(a4i18))*(V(a8i18))))*sin((0+0*time))))))}

Ca4r19 a4r19 0 1 ic=0
Ra4r19 a4r19 0 1e12
Ca4i19 a4i19 0 1 ic=0
Ra4i19 a4i19 0 1e12
Ca8r19 a8r19 0 1 ic=0
Ra8r19 a8r19 0 1e12
Ca8i19 a8i19 0 1 ic=0
Ra8i19 a8i19 0 1e12
Ca12r19 a12r19 0 1 ic=0
Ra12r19 a12r19 0 1e12
Ca12i19 a12i19 0 1 ic=0
Ra12i19 a12i19 0 1e12
B4r19 a4r19 0 I={-(((-0.055*(V(a4r19)))+(-0.16*(V(a4i18)-2*V(a4i19)+V(a4i20)))+(-0.01*((V(a4r19))*(V(a4r19))+(V(a4i19))*(V(a4i19))+(V(a8r19))*(V(a8r19))+(V(a8i19))*(V(a8i19))+(V(a12r19))*(V(a12r19))+(V(a12i19))*(V(a12i19)))*(V(a4r19)))))}
B4i19 a4i19 0 I={-(((-0.055*(V(a4i19)))+(0.16*(V(a4r18)-2*V(a4r19)+V(a4r20)))+(-0.01*((V(a4r19))*(V(a4r19))+(V(a4i19))*(V(a4i19))+(V(a8r19))*(V(a8r19))+(V(a8i19))*(V(a8i19))+(V(a12r19))*(V(a12r19))+(V(a12i19))*(V(a12i19)))*(V(a4i19)))))}
B8r19 a8r19 0 I={-(((-0.0594*(V(a8r19)))+(0*(V(a8i19)))+(-0.1472*(V(a8i18)-2*V(a8i19)+V(a8i20)))+(-0.01*((V(a4r19))*(V(a4r19))+(V(a4i19))*(V(a4i19))+(V(a8r19))*(V(a8r19))+(V(a8i19))*(V(a8i19))+(V(a12r19))*(V(a12r19))+(V(a12i19))*(V(a12i19)))*(V(a8r19)))+(0.055*((((V(a4r19))*(V(a4r19))-(V(a4i19))*(V(a4i19))))*cos((0+0*time))+((2*(V(a4r19))*(V(a4i19))))*sin((0+0*time))))))}
B8i19 a8i19 0 I={-(((-0.0594*(V(a8i19)))+(-0*(V(a8r19)))+(0.1472*(V(a8r18)-2*V(a8r19)+V(a8r20)))+(-0.01*((V(a4r19))*(V(a4r19))+(V(a4i19))*(V(a4i19))+(V(a8r19))*(V(a8r19))+(V(a8i19))*(V(a8i19))+(V(a12r19))*(V(a12r19))+(V(a12i19))*(V(a12i19)))*(V(a8i19)))+(0.055*(((2*(V(a4r19))*(V(a4i19))))*cos((0+0*time))-(((V(a4r19))*(V(a4r19))-(V(a4i19))*(V(a4i19))))*sin((0+0*time))))))}
B12r19 a12r19 0 I={-(((-0.0638*(V(a12r19)))+(0*(V(a12i19)))+(-0.1344*(V(a12i18)-2*V(a12i19)+V(a12i20)))+(-0.01*((V(a4r19))*(V(a4r19))+(V(a4i19))*(V(a4i19))+(V(a8r19))*(V(a8r19))+(V(a8i19))*(V(a8i19))+(V(a12r19))*(V(a12r19))+(V(a12i19))*(V(a12i19)))*(V(a12r19)))+(0.075*((((V(a4r19))*(V(a8r19))-(V(a4i19))*(V(a8i19))))*cos((0+0*time))+(((V(a4r19))*(V(a8i19))+(V(a4i19))*(V(a8r19))))*sin((0+0*time))))))}
B12i19 a12i19 0 I={-(((-0.0638*(V(a12i19)))+(-0*(V(a12r19)))+(0.1344*(V(a12r18)-2*V(a12r19)+V(a12r20)))+(-0.01*((V(a4r19))*(V(a4r19))+(V(a4i19))*(V(a4i19))+(V(a8r19))*(V(a8r19))+(V(a8i19))*(V(a8i19))+(V(a12r19))*(V(a12r19))+(V(a12i19))*(V(a12i19)))*(V(a12i19)))+(0.075*((((V(a4r19))*(V(a8i19))+(V(a4i19))*(V(a8r19))))*cos((0+0*time))-(((V(a4r19))*(V(a8r19))-(V(a4i19))*(V(a8i19))))*sin((0+0*time))))))}

Ca4r20 a4r20 0 1 ic=0
Ra4r20 a4r20 0 1e12
Ca4i20 a4i20 0 1 ic=0
Ra4i20 a4i20 0 1e12
Ca8r20 a8r20 0 1 ic=0
Ra8r20 a8r20 0 1e12
Ca8i20 a8i20 0 1 ic=0
Ra8i20 a8i20 0 1e12
Ca12r20 a12r20 0 1 ic=0
Ra12r20 a12r20 0 1e12
Ca12i20 a12i20 0 1 ic=0
Ra12i20 a12i20 0 1e12
B4r20 a4r20 0 I={-(((-0.055*(V(a4r20)))+(-0.16*(V(a4i19)-2*V(a4i20)+V(a4i21)))+(-0.01*((V(a4r20))*(V(a4r20))+(V(a4i20))*(V(a4i20))+(V(a8r20))*(V(a8r20))+(V(a8i20))*(V(a8i20))+(V(a12r20))*(V(a12r20))+(V(a12i20))*(V(a12i20)))*(V(a4r20)))))}
B4i20 a4i20 0 I={-(((-0.055*(V(a4i20)))+(0.16*(V(a4r19)-2*V(a4r20)+V(a4r21)))+(-0.01*((V(a4r20))*(V(a4r20))+(V(a4i20))*(V(a4i20))+(V(a8r20))*(V(a8r20))+(V(a8i20))*(V(a8i20))+(V(a12r20))*(V(a12r20))+(V(a12i20))*(V(a12i20)))*(V(a4i20)))))}
B8r20 a8r20 0 I={-(((-0.0594*(V(a8r20)))+(0*(V(a8i20)))+(-0.1472*(V(a8i19)-2*V(a8i20)+V(a8i21)))+(-0.01*((V(a4r20))*(V(a4r20))+(V(a4i20))*(V(a4i20))+(V(a8r20))*(V(a8r20))+(V(a8i20))*(V(a8i20))+(V(a12r20))*(V(a12r20))+(V(a12i20))*(V(a12i20)))*(V(a8r20)))+(0.055*((((V(a4r20))*(V(a4r20))-(V(a4i20))*(V(a4i20))))*cos((0+0*time))+((2*(V(a4r20))*(V(a4i20))))*sin((0+0*time))))))}
B8i20 a8i20 0 I={-(((-0.0594*(V(a8i20)))+(-0*(V(a8r20)))+(0.1472*(V(a8r19)-2*V(a8r20)+V(a8r21)))+(-0.01*((V(a4r20))*(V(a4r20))+(V(a4i20))*(V(a4i20))+(V(a8r20))*(V(a8r20))+(V(a8i20))*(V(a8i20))+(V(a12r20))*(V(a12r20))+(V(a12i20))*(V(a12i20)))*(V(a8i20)))+(0.055*(((2*(V(a4r20))*(V(a4i20))))*cos((0+0*time))-(((V(a4r20))*(V(a4r20))-(V(a4i20))*(V(a4i20))))*sin((0+0*time))))))}
B12r20 a12r20 0 I={-(((-0.0638*(V(a12r20)))+(0*(V(a12i20)))+(-0.1344*(V(a12i19)-2*V(a12i20)+V(a12i21)))+(-0.01*((V(a4r20))*(V(a4r20))+(V(a4i20))*(V(a4i20))+(V(a8r20))*(V(a8r20))+(V(a8i20))*(V(a8i20))+(V(a12r20))*(V(a12r20))+(V(a12i20))*(V(a12i20)))*(V(a12r20)))+(0.075*((((V(a4r20))*(V(a8r20))-(V(a4i20))*(V(a8i20))))*cos((0+0*time))+(((V(a4r20))*(V(a8i20))+(V(a4i20))*(V(a8r20))))*sin((0+0*time))))))}
B12i20 a12i20 0 I={-(((-0.0638*(V(a12i20)))+(-0*(V(a12r20)))+(0.1344*(V(a12r19)-2*V(a12r20)+V(a12r21)))+(-0.01*((V(a4r20))*(V(a4r20))+(V(a4i20))*(V(a4i20))+(V(a8r20))*(V(a8r20))+(V(a8i20))*(V(a8i20))+(V(a12r20))*(V(a12r20))+(V(a12i20))*(V(a12i20)))*(V(a12i20)))+(0.075*((((V(a4r20))*(V(a8i20))+(V(a4i20))*(V(a8r20))))*cos((0+0*time))-(((V(a4r20))*(V(a8r20))-(V(a4i20))*(V(a8i20))))*sin((0+0*time))))))}

Ca4r21 a4r21 0 1 ic=0
Ra4r21 a4r21 0 1e12
Ca4i21 a4i21 0 1 ic=0
Ra4i21 a4i21 0 1e12
Ca8r21 a8r21 0 1 ic=0
Ra8r21 a8r21 0 1e12
Ca8i21 a8i21 0 1 ic=0
Ra8i21 a8i21 0 1e12
Ca12r21 a12r21 0 1 ic=0
Ra12r21 a12r21 0 1e12
Ca12i21 a12i21 0 1 ic=0
Ra12i21 a12i21 0 1e12
B4r21 a4r21 0 I={-(((-0.055*(V(a4r21)))+(-0.16*(V(a4i20)-2*V(a4i21)+V(a4i22)))+(-0.01*((V(a4r21))*(V(a4r21))+(V(a4i21))*(V(a4i21))+(V(a8r21))*(V(a8r21))+(V(a8i21))*(V(a8i21))+(V(a12r21))*(V(a12r21))+(V(a12i21))*(V(a12i21)))*(V(a4r21)))))}
B4i21 a4i21 0 I={-(((-0.055*(V(a4i21)))+(0.16*(V(a4r20)-2*V(a4r21)+V(a4r22)))+(-0.01*((V(a4r21))*(V(a4r21))+(V(a4i21))*(V(a4i21))+(V(a8r21))*(V(a8r21))+(V(a8i21))*(V(a8i21))+(V(a12r21))*(V(a12r21))+(V(a12i21))*(V(a12i21)))*(V(a4i21)))))}
B8r21 a8r21 0 I={-(((-0.0594*(V(a8r21)))+(0*(V(a8i21)))+(-0.1472*(V(a8i20)-2*V(a8i21)+V(a8i22)))+(-0.01*((V(a4r21))*(V(a4r21))+(V(a4i21))*(V(a4i21))+(V(a8r21))*(V(a8r21))+(V(a8i21))*(V(a8i21))+(V(a12r21))*(V(a12r21))+(V(a12i21))*(V(a12i21)))*(V(a8r21)))+(0.055*((((V(a4r21))*(V(a4r21))-(V(a4i21))*(V(a4i21))))*cos((0+0*time))+((2*(V(a4r21))*(V(a4i21))))*sin((0+0*time))))))}
B8i21 a8i21 0 I={-(((-0.0594*(V(a8i21)))+(-0*(V(a8r21)))+(0.1472*(V(a8r20)-2*V(a8r21)+V(a8r22)))+(-0.01*((V(a4r21))*(V(a4r21))+(V(a4i21))*(V(a4i21))+(V(a8r21))*(V(a8r21))+(V(a8i21))*(V(a8i21))+(V(a12r21))*(V(a12r21))+(V(a12i21))*(V(a12i21)))*(V(a8i21)))+(0.055*(((2*(V(a4r21))*(V(a4i21))))*cos((0+0*time))-(((V(a4r21))*(V(a4r21))-(V(a4i21))*(V(a4i21))))*sin((0+0*time))))))}
B12r21 a12r21 0 I={-(((-0.0638*(V(a12r21)))+(0*(V(a12i21)))+(-0.1344*(V(a12i20)-2*V(a12i21)+V(a12i22)))+(-0.01*((V(a4r21))*(V(a4r21))+(V(a4i21))*(V(a4i21))+(V(a8r21))*(V(a8r21))+(V(a8i21))*(V(a8i21))+(V(a12r21))*(V(a12r21))+(V(a12i21))*(V(a12i21)))*(V(a12r21)))+(0.075*((((V(a4r21))*(V(a8r21))-(V(a4i21))*(V(a8i21))))*cos((0+0*time))+(((V(a4r21))*(V(a8i21))+(V(a4i21))*(V(a8r21))))*sin((0+0*time))))))}
B12i21 a12i21 0 I={-(((-0.0638*(V(a12i21)))+(-0*(V(a12r21)))+(0.1344*(V(a12r20)-2*V(a12r21)+V(a12r22)))+(-0.01*((V(a4r21))*(V(a4r21))+(V(a4i21))*(V(a4i21))+(V(a8r21))*(V(a8r21))+(V(a8i21))*(V(a8i21))+(V(a12r21))*(V(a12r21))+(V(a12i21))*(V(a12i21)))*(V(a12i21)))+(0.075*((((V(a4r21))*(V(a8i21))+(V(a4i21))*(V(a8r21))))*cos((0+0*time))-(((V(a4r21))*(V(a8r21))-(V(a4i21))*(V(a8i21))))*sin((0+0*time))))))}

Ca4r22 a4r22 0 1 ic=0
Ra4r22 a4r22 0 1e12
Ca4i22 a4i22 0 1 ic=0
Ra4i22 a4i22 0 1e12
Ca8r22 a8r22 0 1 ic=0
Ra8r22 a8r22 0 1e12
Ca8i22 a8i22 0 1 ic=0
Ra8i22 a8i22 0 1e12
Ca12r22 a12r22 0 1 ic=0
Ra12r22 a12r22 0 1e12
Ca12i22 a12i22 0 1 ic=0
Ra12i22 a12i22 0 1e12
B4r22 a4r22 0 I={-(((-0.055*(V(a4r22)))+(-0.16*(V(a4i21)-2*V(a4i22)+V(a4i23)))+(-0.01*((V(a4r22))*(V(a4r22))+(V(a4i22))*(V(a4i22))+(V(a8r22))*(V(a8r22))+(V(a8i22))*(V(a8i22))+(V(a12r22))*(V(a12r22))+(V(a12i22))*(V(a12i22)))*(V(a4r22)))))}
B4i22 a4i22 0 I={-(((-0.055*(V(a4i22)))+(0.16*(V(a4r21)-2*V(a4r22)+V(a4r23)))+(-0.01*((V(a4r22))*(V(a4r22))+(V(a4i22))*(V(a4i22))+(V(a8r22))*(V(a8r22))+(V(a8i22))*(V(a8i22))+(V(a12r22))*(V(a12r22))+(V(a12i22))*(V(a12i22)))*(V(a4i22)))))}
B8r22 a8r22 0 I={-(((-0.0594*(V(a8r22)))+(0*(V(a8i22)))+(-0.1472*(V(a8i21)-2*V(a8i22)+V(a8i23)))+(-0.01*((V(a4r22))*(V(a4r22))+(V(a4i22))*(V(a4i22))+(V(a8r22))*(V(a8r22))+(V(a8i22))*(V(a8i22))+(V(a12r22))*(V(a12r22))+(V(a12i22))*(V(a12i22)))*(V(a8r22)))+(0.055*((((V(a4r22))*(V(a4r22))-(V(a4i22))*(V(a4i22))))*cos((0+0*time))+((2*(V(a4r22))*(V(a4i22))))*sin((0+0*time))))))}
B8i22 a8i22 0 I={-(((-0.0594*(V(a8i22)))+(-0*(V(a8r22)))+(0.1472*(V(a8r21)-2*V(a8r22)+V(a8r23)))+(-0.01*((V(a4r22))*(V(a4r22))+(V(a4i22))*(V(a4i22))+(V(a8r22))*(V(a8r22))+(V(a8i22))*(V(a8i22))+(V(a12r22))*(V(a12r22))+(V(a12i22))*(V(a12i22)))*(V(a8i22)))+(0.055*(((2*(V(a4r22))*(V(a4i22))))*cos((0+0*time))-(((V(a4r22))*(V(a4r22))-(V(a4i22))*(V(a4i22))))*sin((0+0*time))))))}
B12r22 a12r22 0 I={-(((-0.0638*(V(a12r22)))+(0*(V(a12i22)))+(-0.1344*(V(a12i21)-2*V(a12i22)+V(a12i23)))+(-0.01*((V(a4r22))*(V(a4r22))+(V(a4i22))*(V(a4i22))+(V(a8r22))*(V(a8r22))+(V(a8i22))*(V(a8i22))+(V(a12r22))*(V(a12r22))+(V(a12i22))*(V(a12i22)))*(V(a12r22)))+(0.075*((((V(a4r22))*(V(a8r22))-(V(a4i22))*(V(a8i22))))*cos((0+0*time))+(((V(a4r22))*(V(a8i22))+(V(a4i22))*(V(a8r22))))*sin((0+0*time))))))}
B12i22 a12i22 0 I={-(((-0.0638*(V(a12i22)))+(-0*(V(a12r22)))+(0.1344*(V(a12r21)-2*V(a12r22)+V(a12r23)))+(-0.01*((V(a4r22))*(V(a4r22))+(V(a4i22))*(V(a4i22))+(V(a8r22))*(V(a8r22))+(V(a8i22))*(V(a8i22))+(V(a12r22))*(V(a12r22))+(V(a12i22))*(V(a12i22)))*(V(a12i22)))+(0.075*((((V(a4r22))*(V(a8i22))+(V(a4i22))*(V(a8r22))))*cos((0+0*time))-(((V(a4r22))*(V(a8r22))-(V(a4i22))*(V(a8i22))))*sin((0+0*time))))))}

Ca4r23 a4r23 0 1 ic=0
Ra4r23 a4r23 0 1e12
Ca4i23 a4i23 0 1 ic=0
Ra4i23 a4i23 0 1e12
Ca8r23 a8r23 0 1 ic=0
Ra8r23 a8r23 0 1e12
Ca8i23 a8i23 0 1 ic=0
Ra8i23 a8i23 0 1e12
Ca12r23 a12r23 0 1 ic=0
Ra12r23 a12r23 0 1e12
Ca12i23 a12i23 0 1 ic=0
Ra12i23 a12i23 0 1e12
B4r23 a4r23 0 I={-(((-0.055*(V(a4r23)))+(-0.16*(V(a4i22)-V(a4i23)))+(-0.01*((V(a4r23))*(V(a4r23))+(V(a4i23))*(V(a4i23))+(V(a8r23))*(V(a8r23))+(V(a8i23))*(V(a8i23))+(V(a12r23))*(V(a12r23))+(V(a12i23))*(V(a12i23)))*(V(a4r23)))))}
B4i23 a4i23 0 I={-(((-0.055*(V(a4i23)))+(0.16*(V(a4r22)-V(a4r23)))+(-0.01*((V(a4r23))*(V(a4r23))+(V(a4i23))*(V(a4i23))+(V(a8r23))*(V(a8r23))+(V(a8i23))*(V(a8i23))+(V(a12r23))*(V(a12r23))+(V(a12i23))*(V(a12i23)))*(V(a4i23)))))}
B8r23 a8r23 0 I={-(((-0.0594*(V(a8r23)))+(0*(V(a8i23)))+(-0.1472*(V(a8i22)-V(a8i23)))+(-0.01*((V(a4r23))*(V(a4r23))+(V(a4i23))*(V(a4i23))+(V(a8r23))*(V(a8r23))+(V(a8i23))*(V(a8i23))+(V(a12r23))*(V(a12r23))+(V(a12i23))*(V(a12i23)))*(V(a8r23)))+(0.055*((((V(a4r23))*(V(a4r23))-(V(a4i23))*(V(a4i23))))*cos((0+0*time))+((2*(V(a4r23))*(V(a4i23))))*sin((0+0*time))))))}
B8i23 a8i23 0 I={-(((-0.0594*(V(a8i23)))+(-0*(V(a8r23)))+(0.1472*(V(a8r22)-V(a8r23)))+(-0.01*((V(a4r23))*(V(a4r23))+(V(a4i23))*(V(a4i23))+(V(a8r23))*(V(a8r23))+(V(a8i23))*(V(a8i23))+(V(a12r23))*(V(a12r23))+(V(a12i23))*(V(a12i23)))*(V(a8i23)))+(0.055*(((2*(V(a4r23))*(V(a4i23))))*cos((0+0*time))-(((V(a4r23))*(V(a4r23))-(V(a4i23))*(V(a4i23))))*sin((0+0*time))))))}
B12r23 a12r23 0 I={-(((-0.0638*(V(a12r23)))+(0*(V(a12i23)))+(-0.1344*(V(a12i22)-V(a12i23)))+(-0.01*((V(a4r23))*(V(a4r23))+(V(a4i23))*(V(a4i23))+(V(a8r23))*(V(a8r23))+(V(a8i23))*(V(a8i23))+(V(a12r23))*(V(a12r23))+(V(a12i23))*(V(a12i23)))*(V(a12r23)))+(0.075*((((V(a4r23))*(V(a8r23))-(V(a4i23))*(V(a8i23))))*cos((0+0*time))+(((V(a4r23))*(V(a8i23))+(V(a4i23))*(V(a8r23))))*sin((0+0*time))))))}
B12i23 a12i23 0 I={-(((-0.0638*(V(a12i23)))+(-0*(V(a12r23)))+(0.1344*(V(a12r22)-V(a12r23)))+(-0.01*((V(a4r23))*(V(a4r23))+(V(a4i23))*(V(a4i23))+(V(a8r23))*(V(a8r23))+(V(a8i23))*(V(a8i23))+(V(a12r23))*(V(a12r23))+(V(a12i23))*(V(a12i23)))*(V(a12i23)))+(0.075*((((V(a4r23))*(V(a8i23))+(V(a4i23))*(V(a8r23))))*cos((0+0*time))-(((V(a4r23))*(V(a8r23))-(V(a4i23))*(V(a8i23))))*sin((0+0*time))))))}

Bobs4r obs4r 0 V={(4.76781769305e-06*V(a4r0)+1.14807459236e-05*V(a4r1)+2.6586326128e-05*V(a4r2)+5.92085338427e-05*V(a4r3)+0.000126808405928*V(a4r4)+0.000261185784828*V(a4r5)+0.000517355162382*V(a4r6)+0.000985520799645*V(a4r7)+0.00180542960359*V(a4r8)+0.00318077596544*V(a4r9)+0.0053891883223*V(a4r10)+0.00878115000493*V(a4r11)+0.0137599605656*V(a4r12)+0.0207357973344*V(a4r13)+0.0300512157818*V(a4r14)+0.0418833211093*V(a4r15)+0.056138128862*V(a4r16)+0.0723623249245*V(a4r17)+0.0897025621161*V(a4r18)+0.106938709941*V(a4r19)+0.122603478112*V(a4r20)+0.135178741215*V(a4r21)+0.143334838786*V(a4r22)+0.146161463779*V(a4r23))}
Bobs4i obs4i 0 V={(4.76781769305e-06*V(a4i0)+1.14807459236e-05*V(a4i1)+2.6586326128e-05*V(a4i2)+5.92085338427e-05*V(a4i3)+0.000126808405928*V(a4i4)+0.000261185784828*V(a4i5)+0.000517355162382*V(a4i6)+0.000985520799645*V(a4i7)+0.00180542960359*V(a4i8)+0.00318077596544*V(a4i9)+0.0053891883223*V(a4i10)+0.00878115000493*V(a4i11)+0.0137599605656*V(a4i12)+0.0207357973344*V(a4i13)+0.0300512157818*V(a4i14)+0.0418833211093*V(a4i15)+0.056138128862*V(a4i16)+0.0723623249245*V(a4i17)+0.0897025621161*V(a4i18)+0.106938709941*V(a4i19)+0.122603478112*V(a4i20)+0.135178741215*V(a4i21)+0.143334838786*V(a4i22)+0.146161463779*V(a4i23))}
Bobs8r obs8r 0 V={(4.76781769305e-06*V(a8r0)+1.14807459236e-05*V(a8r1)+2.6586326128e-05*V(a8r2)+5.92085338427e-05*V(a8r3)+0.000126808405928*V(a8r4)+0.000261185784828*V(a8r5)+0.000517355162382*V(a8r6)+0.000985520799645*V(a8r7)+0.00180542960359*V(a8r8)+0.00318077596544*V(a8r9)+0.0053891883223*V(a8r10)+0.00878115000493*V(a8r11)+0.0137599605656*V(a8r12)+0.0207357973344*V(a8r13)+0.0300512157818*V(a8r14)+0.0418833211093*V(a8r15)+0.056138128862*V(a8r16)+0.0723623249245*V(a8r17)+0.0897025621161*V(a8r18)+0.106938709941*V(a8r19)+0.122603478112*V(a8r20)+0.135178741215*V(a8r21)+0.143334838786*V(a8r22)+0.146161463779*V(a8r23))}
Bobs8i obs8i 0 V={(4.76781769305e-06*V(a8i0)+1.14807459236e-05*V(a8i1)+2.6586326128e-05*V(a8i2)+5.92085338427e-05*V(a8i3)+0.000126808405928*V(a8i4)+0.000261185784828*V(a8i5)+0.000517355162382*V(a8i6)+0.000985520799645*V(a8i7)+0.00180542960359*V(a8i8)+0.00318077596544*V(a8i9)+0.0053891883223*V(a8i10)+0.00878115000493*V(a8i11)+0.0137599605656*V(a8i12)+0.0207357973344*V(a8i13)+0.0300512157818*V(a8i14)+0.0418833211093*V(a8i15)+0.056138128862*V(a8i16)+0.0723623249245*V(a8i17)+0.0897025621161*V(a8i18)+0.106938709941*V(a8i19)+0.122603478112*V(a8i20)+0.135178741215*V(a8i21)+0.143334838786*V(a8i22)+0.146161463779*V(a8i23))}
Bobs12r obs12r 0 V={(4.76781769305e-06*V(a12r0)+1.14807459236e-05*V(a12r1)+2.6586326128e-05*V(a12r2)+5.92085338427e-05*V(a12r3)+0.000126808405928*V(a12r4)+0.000261185784828*V(a12r5)+0.000517355162382*V(a12r6)+0.000985520799645*V(a12r7)+0.00180542960359*V(a12r8)+0.00318077596544*V(a12r9)+0.0053891883223*V(a12r10)+0.00878115000493*V(a12r11)+0.0137599605656*V(a12r12)+0.0207357973344*V(a12r13)+0.0300512157818*V(a12r14)+0.0418833211093*V(a12r15)+0.056138128862*V(a12r16)+0.0723623249245*V(a12r17)+0.0897025621161*V(a12r18)+0.106938709941*V(a12r19)+0.122603478112*V(a12r20)+0.135178741215*V(a12r21)+0.143334838786*V(a12r22)+0.146161463779*V(a12r23))}
Bobs12i obs12i 0 V={(4.76781769305e-06*V(a12i0)+1.14807459236e-05*V(a12i1)+2.6586326128e-05*V(a12i2)+5.92085338427e-05*V(a12i3)+0.000126808405928*V(a12i4)+0.000261185784828*V(a12i5)+0.000517355162382*V(a12i6)+0.000985520799645*V(a12i7)+0.00180542960359*V(a12i8)+0.00318077596544*V(a12i9)+0.0053891883223*V(a12i10)+0.00878115000493*V(a12i11)+0.0137599605656*V(a12i12)+0.0207357973344*V(a12i13)+0.0300512157818*V(a12i14)+0.0418833211093*V(a12i15)+0.056138128862*V(a12i16)+0.0723623249245*V(a12i17)+0.0897025621161*V(a12i18)+0.106938709941*V(a12i19)+0.122603478112*V(a12i20)+0.135178741215*V(a12i21)+0.143334838786*V(a12i22)+0.146161463779*V(a12i23))}

.control
set noaskquit
set filetype=ascii
tran 0.04 96 0 0.04 uic
wrdata direct_4plus8_ceiling_reference_tran.csv v(obs4r) v(obs4i) v(obs8r) v(obs8i) v(obs12r) v(obs12i) v(a4r0) v(a4i0) v(a8r0) v(a8i0) v(a12r0) v(a12i0) v(a4r1) v(a4i1) v(a8r1) v(a8i1) v(a12r1) v(a12i1) v(a4r2) v(a4i2) v(a8r2) v(a8i2) v(a12r2) v(a12i2) v(a4r3) v(a4i3) v(a8r3) v(a8i3) v(a12r3) v(a12i3) v(a4r4) v(a4i4) v(a8r4) v(a8i4) v(a12r4) v(a12i4) v(a4r5) v(a4i5) v(a8r5) v(a8i5) v(a12r5) v(a12i5) v(a4r6) v(a4i6) v(a8r6) v(a8i6) v(a12r6) v(a12i6) v(a4r7) v(a4i7) v(a8r7) v(a8i7) v(a12r7) v(a12i7) v(a4r8) v(a4i8) v(a8r8) v(a8i8) v(a12r8) v(a12i8) v(a4r9) v(a4i9) v(a8r9) v(a8i9) v(a12r9) v(a12i9) v(a4r10) v(a4i10) v(a8r10) v(a8i10) v(a12r10) v(a12i10) v(a4r11) v(a4i11) v(a8r11) v(a8i11) v(a12r11) v(a12i11) v(a4r12) v(a4i12) v(a8r12) v(a8i12) v(a12r12) v(a12i12) v(a4r13) v(a4i13) v(a8r13) v(a8i13) v(a12r13) v(a12i13) v(a4r14) v(a4i14) v(a8r14) v(a8i14) v(a12r14) v(a12i14) v(a4r15) v(a4i15) v(a8r15) v(a8i15) v(a12r15) v(a12i15) v(a4r16) v(a4i16) v(a8r16) v(a8i16) v(a12r16) v(a12i16) v(a4r17) v(a4i17) v(a8r17) v(a8i17) v(a12r17) v(a12i17) v(a4r18) v(a4i18) v(a8r18) v(a8i18) v(a12r18) v(a12i18) v(a4r19) v(a4i19) v(a8r19) v(a8i19) v(a12r19) v(a12i19) v(a4r20) v(a4i20) v(a8r20) v(a8i20) v(a12r20) v(a12i20) v(a4r21) v(a4i21) v(a8r21) v(a8i21) v(a12r21) v(a12i21) v(a4r22) v(a4i22) v(a8r22) v(a8i22) v(a12r22) v(a12i22) v(a4r23) v(a4i23) v(a8r23) v(a8i23) v(a12r23) v(a12i23)
quit
.endc
.end

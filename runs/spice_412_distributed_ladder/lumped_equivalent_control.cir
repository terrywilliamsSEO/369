* lumped_equivalent_control
* Normalized distributed envelope ladder for 4->8->12 phase matching.
* topology=compact_lumped_equivalent_control role=control
* Source-only discovery rule: direct 8 and direct 12 drives are absent unless role=ceiling_reference.
.options reltol=1e-4 abstol=1e-8 chgtol=1e-12 method=gear maxord=2
.param tstep=0.04
.param tstop=96

Ca4r0 a4r0 0 1 ic=0
Ra4r0 a4r0 0 1e12
Ca4i0 a4i0 0 1 ic=0
Ra4i0 a4i0 0 1e12
Ca8r0 a8r0 0 1 ic=0
Ra8r0 a8r0 0 1e12
Ca8i0 a8i0 0 1 ic=0
Ra8i0 a8i0 0 1e12
Ca12r0 a12r0 0 1 ic=0
Ra12r0 a12r0 0 1e12
Ca12i0 a12i0 0 1 ic=0
Ra12i0 a12i0 0 1e12
B4r0 a4r0 0 I={-(((-0.045*(V(a4r0)))+(-0.16*(V(a4i1)-V(a4i0)))+(-0.01*((V(a4r0))*(V(a4r0))+(V(a4i0))*(V(a4i0))+(V(a8r0))*(V(a8r0))+(V(a8i0))*(V(a8i0))+(V(a12r0))*(V(a12r0))+(V(a12i0))*(V(a12i0)))*(V(a4r0)))))}
B4i0 a4i0 0 I={-(((-0.045*(V(a4i0)))+(0.16*(V(a4r1)-V(a4r0)))+(-0.01*((V(a4r0))*(V(a4r0))+(V(a4i0))*(V(a4i0))+(V(a8r0))*(V(a8r0))+(V(a8i0))*(V(a8i0))+(V(a12r0))*(V(a12r0))+(V(a12i0))*(V(a12i0)))*(V(a4i0)))))}
B8r0 a8r0 0 I={-(((-0.0486*(V(a8r0)))+(0*(V(a8i0)))+(-0.1472*(V(a8i1)-V(a8i0)))+(-0.01*((V(a4r0))*(V(a4r0))+(V(a4i0))*(V(a4i0))+(V(a8r0))*(V(a8r0))+(V(a8i0))*(V(a8i0))+(V(a12r0))*(V(a12r0))+(V(a12i0))*(V(a12i0)))*(V(a8r0)))+(0.06*((((V(a4r0))*(V(a4r0))-(V(a4i0))*(V(a4i0))))*cos((0+0.04*time))+((2*(V(a4r0))*(V(a4i0))))*sin((0+0.04*time))))))}
B8i0 a8i0 0 I={-(((-0.0486*(V(a8i0)))+(-0*(V(a8r0)))+(0.1472*(V(a8r1)-V(a8r0)))+(-0.01*((V(a4r0))*(V(a4r0))+(V(a4i0))*(V(a4i0))+(V(a8r0))*(V(a8r0))+(V(a8i0))*(V(a8i0))+(V(a12r0))*(V(a12r0))+(V(a12i0))*(V(a12i0)))*(V(a8i0)))+(0.06*(((2*(V(a4r0))*(V(a4i0))))*cos((0+0.04*time))-(((V(a4r0))*(V(a4r0))-(V(a4i0))*(V(a4i0))))*sin((0+0.04*time))))))}
B12r0 a12r0 0 I={-(((-0.0522*(V(a12r0)))+(0*(V(a12i0)))+(-0.1344*(V(a12i1)-V(a12i0)))+(-0.01*((V(a4r0))*(V(a4r0))+(V(a4i0))*(V(a4i0))+(V(a8r0))*(V(a8r0))+(V(a8i0))*(V(a8i0))+(V(a12r0))*(V(a12r0))+(V(a12i0))*(V(a12i0)))*(V(a12r0)))+(0.075*((((V(a4r0))*(V(a8r0))-(V(a4i0))*(V(a8i0))))*cos((0+-0.06*time))+(((V(a4r0))*(V(a8i0))+(V(a4i0))*(V(a8r0))))*sin((0+-0.06*time))))))}
B12i0 a12i0 0 I={-(((-0.0522*(V(a12i0)))+(-0*(V(a12r0)))+(0.1344*(V(a12r1)-V(a12r0)))+(-0.01*((V(a4r0))*(V(a4r0))+(V(a4i0))*(V(a4i0))+(V(a8r0))*(V(a8r0))+(V(a8i0))*(V(a8i0))+(V(a12r0))*(V(a12r0))+(V(a12i0))*(V(a12i0)))*(V(a12i0)))+(0.075*((((V(a4r0))*(V(a8i0))+(V(a4i0))*(V(a8r0))))*cos((0+-0.06*time))-(((V(a4r0))*(V(a8r0))-(V(a4i0))*(V(a8i0))))*sin((0+-0.06*time))))))}
Idrive4_0 a4r0 0 PWL(0 0 11.52 -0.2 78.72 -0.2 96 0)

Ca4r1 a4r1 0 1 ic=0
Ra4r1 a4r1 0 1e12
Ca4i1 a4i1 0 1 ic=0
Ra4i1 a4i1 0 1e12
Ca8r1 a8r1 0 1 ic=0
Ra8r1 a8r1 0 1e12
Ca8i1 a8i1 0 1 ic=0
Ra8i1 a8i1 0 1e12
Ca12r1 a12r1 0 1 ic=0
Ra12r1 a12r1 0 1e12
Ca12i1 a12i1 0 1 ic=0
Ra12i1 a12i1 0 1e12
B4r1 a4r1 0 I={-(((-0.045*(V(a4r1)))+(-0.16*(V(a4i0)-2*V(a4i1)+V(a4i2)))+(-0.01*((V(a4r1))*(V(a4r1))+(V(a4i1))*(V(a4i1))+(V(a8r1))*(V(a8r1))+(V(a8i1))*(V(a8i1))+(V(a12r1))*(V(a12r1))+(V(a12i1))*(V(a12i1)))*(V(a4r1)))))}
B4i1 a4i1 0 I={-(((-0.045*(V(a4i1)))+(0.16*(V(a4r0)-2*V(a4r1)+V(a4r2)))+(-0.01*((V(a4r1))*(V(a4r1))+(V(a4i1))*(V(a4i1))+(V(a8r1))*(V(a8r1))+(V(a8i1))*(V(a8i1))+(V(a12r1))*(V(a12r1))+(V(a12i1))*(V(a12i1)))*(V(a4i1)))))}
B8r1 a8r1 0 I={-(((-0.0486*(V(a8r1)))+(0*(V(a8i1)))+(-0.1472*(V(a8i0)-2*V(a8i1)+V(a8i2)))+(-0.01*((V(a4r1))*(V(a4r1))+(V(a4i1))*(V(a4i1))+(V(a8r1))*(V(a8r1))+(V(a8i1))*(V(a8i1))+(V(a12r1))*(V(a12r1))+(V(a12i1))*(V(a12i1)))*(V(a8r1)))+(0.06*((((V(a4r1))*(V(a4r1))-(V(a4i1))*(V(a4i1))))*cos((0.157142857143+0.04*time))+((2*(V(a4r1))*(V(a4i1))))*sin((0.157142857143+0.04*time))))))}
B8i1 a8i1 0 I={-(((-0.0486*(V(a8i1)))+(-0*(V(a8r1)))+(0.1472*(V(a8r0)-2*V(a8r1)+V(a8r2)))+(-0.01*((V(a4r1))*(V(a4r1))+(V(a4i1))*(V(a4i1))+(V(a8r1))*(V(a8r1))+(V(a8i1))*(V(a8i1))+(V(a12r1))*(V(a12r1))+(V(a12i1))*(V(a12i1)))*(V(a8i1)))+(0.06*(((2*(V(a4r1))*(V(a4i1))))*cos((0.157142857143+0.04*time))-(((V(a4r1))*(V(a4r1))-(V(a4i1))*(V(a4i1))))*sin((0.157142857143+0.04*time))))))}
B12r1 a12r1 0 I={-(((-0.0522*(V(a12r1)))+(0*(V(a12i1)))+(-0.1344*(V(a12i0)-2*V(a12i1)+V(a12i2)))+(-0.01*((V(a4r1))*(V(a4r1))+(V(a4i1))*(V(a4i1))+(V(a8r1))*(V(a8r1))+(V(a8i1))*(V(a8i1))+(V(a12r1))*(V(a12r1))+(V(a12i1))*(V(a12i1)))*(V(a12r1)))+(0.075*((((V(a4r1))*(V(a8r1))-(V(a4i1))*(V(a8i1))))*cos((0.2+-0.06*time))+(((V(a4r1))*(V(a8i1))+(V(a4i1))*(V(a8r1))))*sin((0.2+-0.06*time))))))}
B12i1 a12i1 0 I={-(((-0.0522*(V(a12i1)))+(-0*(V(a12r1)))+(0.1344*(V(a12r0)-2*V(a12r1)+V(a12r2)))+(-0.01*((V(a4r1))*(V(a4r1))+(V(a4i1))*(V(a4i1))+(V(a8r1))*(V(a8r1))+(V(a8i1))*(V(a8i1))+(V(a12r1))*(V(a12r1))+(V(a12i1))*(V(a12i1)))*(V(a12i1)))+(0.075*((((V(a4r1))*(V(a8i1))+(V(a4i1))*(V(a8r1))))*cos((0.2+-0.06*time))-(((V(a4r1))*(V(a8r1))-(V(a4i1))*(V(a8i1))))*sin((0.2+-0.06*time))))))}
Idrive4_1 a4r1 0 PWL(0 0 11.52 -0.0406065592502 78.72 -0.0406065592502 96 0)

Ca4r2 a4r2 0 1 ic=0
Ra4r2 a4r2 0 1e12
Ca4i2 a4i2 0 1 ic=0
Ra4i2 a4i2 0 1e12
Ca8r2 a8r2 0 1 ic=0
Ra8r2 a8r2 0 1e12
Ca8i2 a8i2 0 1 ic=0
Ra8i2 a8i2 0 1e12
Ca12r2 a12r2 0 1 ic=0
Ra12r2 a12r2 0 1e12
Ca12i2 a12i2 0 1 ic=0
Ra12i2 a12i2 0 1e12
B4r2 a4r2 0 I={-(((-0.045*(V(a4r2)))+(-0.16*(V(a4i1)-2*V(a4i2)+V(a4i3)))+(-0.01*((V(a4r2))*(V(a4r2))+(V(a4i2))*(V(a4i2))+(V(a8r2))*(V(a8r2))+(V(a8i2))*(V(a8i2))+(V(a12r2))*(V(a12r2))+(V(a12i2))*(V(a12i2)))*(V(a4r2)))))}
B4i2 a4i2 0 I={-(((-0.045*(V(a4i2)))+(0.16*(V(a4r1)-2*V(a4r2)+V(a4r3)))+(-0.01*((V(a4r2))*(V(a4r2))+(V(a4i2))*(V(a4i2))+(V(a8r2))*(V(a8r2))+(V(a8i2))*(V(a8i2))+(V(a12r2))*(V(a12r2))+(V(a12i2))*(V(a12i2)))*(V(a4i2)))))}
B8r2 a8r2 0 I={-(((-0.0486*(V(a8r2)))+(0*(V(a8i2)))+(-0.1472*(V(a8i1)-2*V(a8i2)+V(a8i3)))+(-0.01*((V(a4r2))*(V(a4r2))+(V(a4i2))*(V(a4i2))+(V(a8r2))*(V(a8r2))+(V(a8i2))*(V(a8i2))+(V(a12r2))*(V(a12r2))+(V(a12i2))*(V(a12i2)))*(V(a8r2)))+(0.06*((((V(a4r2))*(V(a4r2))-(V(a4i2))*(V(a4i2))))*cos((0.314285714286+0.04*time))+((2*(V(a4r2))*(V(a4i2))))*sin((0.314285714286+0.04*time))))))}
B8i2 a8i2 0 I={-(((-0.0486*(V(a8i2)))+(-0*(V(a8r2)))+(0.1472*(V(a8r1)-2*V(a8r2)+V(a8r3)))+(-0.01*((V(a4r2))*(V(a4r2))+(V(a4i2))*(V(a4i2))+(V(a8r2))*(V(a8r2))+(V(a8i2))*(V(a8i2))+(V(a12r2))*(V(a12r2))+(V(a12i2))*(V(a12i2)))*(V(a8i2)))+(0.06*(((2*(V(a4r2))*(V(a4i2))))*cos((0.314285714286+0.04*time))-(((V(a4r2))*(V(a4r2))-(V(a4i2))*(V(a4i2))))*sin((0.314285714286+0.04*time))))))}
B12r2 a12r2 0 I={-(((-0.0522*(V(a12r2)))+(0*(V(a12i2)))+(-0.1344*(V(a12i1)-2*V(a12i2)+V(a12i3)))+(-0.01*((V(a4r2))*(V(a4r2))+(V(a4i2))*(V(a4i2))+(V(a8r2))*(V(a8r2))+(V(a8i2))*(V(a8i2))+(V(a12r2))*(V(a12r2))+(V(a12i2))*(V(a12i2)))*(V(a12r2)))+(0.075*((((V(a4r2))*(V(a8r2))-(V(a4i2))*(V(a8i2))))*cos((0.4+-0.06*time))+(((V(a4r2))*(V(a8i2))+(V(a4i2))*(V(a8r2))))*sin((0.4+-0.06*time))))))}
B12i2 a12i2 0 I={-(((-0.0522*(V(a12i2)))+(-0*(V(a12r2)))+(0.1344*(V(a12r1)-2*V(a12r2)+V(a12r3)))+(-0.01*((V(a4r2))*(V(a4r2))+(V(a4i2))*(V(a4i2))+(V(a8r2))*(V(a8r2))+(V(a8i2))*(V(a8i2))+(V(a12r2))*(V(a12r2))+(V(a12i2))*(V(a12i2)))*(V(a12i2)))+(0.075*((((V(a4r2))*(V(a8i2))+(V(a4i2))*(V(a8r2))))*cos((0.4+-0.06*time))-(((V(a4r2))*(V(a8r2))-(V(a4i2))*(V(a8i2))))*sin((0.4+-0.06*time))))))}
Idrive4_2 a4r2 0 PWL(0 0 11.52 -0.000339855873111 78.72 -0.000339855873111 96 0)

Ca4r3 a4r3 0 1 ic=0
Ra4r3 a4r3 0 1e12
Ca4i3 a4i3 0 1 ic=0
Ra4i3 a4i3 0 1e12
Ca8r3 a8r3 0 1 ic=0
Ra8r3 a8r3 0 1e12
Ca8i3 a8i3 0 1 ic=0
Ra8i3 a8i3 0 1e12
Ca12r3 a12r3 0 1 ic=0
Ra12r3 a12r3 0 1e12
Ca12i3 a12i3 0 1 ic=0
Ra12i3 a12i3 0 1e12
B4r3 a4r3 0 I={-(((-0.045*(V(a4r3)))+(-0.16*(V(a4i2)-2*V(a4i3)+V(a4i4)))+(-0.01*((V(a4r3))*(V(a4r3))+(V(a4i3))*(V(a4i3))+(V(a8r3))*(V(a8r3))+(V(a8i3))*(V(a8i3))+(V(a12r3))*(V(a12r3))+(V(a12i3))*(V(a12i3)))*(V(a4r3)))))}
B4i3 a4i3 0 I={-(((-0.045*(V(a4i3)))+(0.16*(V(a4r2)-2*V(a4r3)+V(a4r4)))+(-0.01*((V(a4r3))*(V(a4r3))+(V(a4i3))*(V(a4i3))+(V(a8r3))*(V(a8r3))+(V(a8i3))*(V(a8i3))+(V(a12r3))*(V(a12r3))+(V(a12i3))*(V(a12i3)))*(V(a4i3)))))}
B8r3 a8r3 0 I={-(((-0.0486*(V(a8r3)))+(0*(V(a8i3)))+(-0.1472*(V(a8i2)-2*V(a8i3)+V(a8i4)))+(-0.01*((V(a4r3))*(V(a4r3))+(V(a4i3))*(V(a4i3))+(V(a8r3))*(V(a8r3))+(V(a8i3))*(V(a8i3))+(V(a12r3))*(V(a12r3))+(V(a12i3))*(V(a12i3)))*(V(a8r3)))+(0.06*((((V(a4r3))*(V(a4r3))-(V(a4i3))*(V(a4i3))))*cos((0.471428571429+0.04*time))+((2*(V(a4r3))*(V(a4i3))))*sin((0.471428571429+0.04*time))))))}
B8i3 a8i3 0 I={-(((-0.0486*(V(a8i3)))+(-0*(V(a8r3)))+(0.1472*(V(a8r2)-2*V(a8r3)+V(a8r4)))+(-0.01*((V(a4r3))*(V(a4r3))+(V(a4i3))*(V(a4i3))+(V(a8r3))*(V(a8r3))+(V(a8i3))*(V(a8i3))+(V(a12r3))*(V(a12r3))+(V(a12i3))*(V(a12i3)))*(V(a8i3)))+(0.06*(((2*(V(a4r3))*(V(a4i3))))*cos((0.471428571429+0.04*time))-(((V(a4r3))*(V(a4r3))-(V(a4i3))*(V(a4i3))))*sin((0.471428571429+0.04*time))))))}
B12r3 a12r3 0 I={-(((-0.0522*(V(a12r3)))+(0*(V(a12i3)))+(-0.1344*(V(a12i2)-2*V(a12i3)+V(a12i4)))+(-0.01*((V(a4r3))*(V(a4r3))+(V(a4i3))*(V(a4i3))+(V(a8r3))*(V(a8r3))+(V(a8i3))*(V(a8i3))+(V(a12r3))*(V(a12r3))+(V(a12i3))*(V(a12i3)))*(V(a12r3)))+(0.075*((((V(a4r3))*(V(a8r3))-(V(a4i3))*(V(a8i3))))*cos((0.6+-0.06*time))+(((V(a4r3))*(V(a8i3))+(V(a4i3))*(V(a8r3))))*sin((0.6+-0.06*time))))))}
B12i3 a12i3 0 I={-(((-0.0522*(V(a12i3)))+(-0*(V(a12r3)))+(0.1344*(V(a12r2)-2*V(a12r3)+V(a12r4)))+(-0.01*((V(a4r3))*(V(a4r3))+(V(a4i3))*(V(a4i3))+(V(a8r3))*(V(a8r3))+(V(a8i3))*(V(a8i3))+(V(a12r3))*(V(a12r3))+(V(a12i3))*(V(a12i3)))*(V(a12i3)))+(0.075*((((V(a4r3))*(V(a8i3))+(V(a4i3))*(V(a8r3))))*cos((0.6+-0.06*time))-(((V(a4r3))*(V(a8r3))-(V(a4i3))*(V(a8i3))))*sin((0.6+-0.06*time))))))}
Idrive4_3 a4r3 0 PWL(0 0 11.52 -1.1725348487e-07 78.72 -1.1725348487e-07 96 0)

Ca4r4 a4r4 0 1 ic=0
Ra4r4 a4r4 0 1e12
Ca4i4 a4i4 0 1 ic=0
Ra4i4 a4i4 0 1e12
Ca8r4 a8r4 0 1 ic=0
Ra8r4 a8r4 0 1e12
Ca8i4 a8i4 0 1 ic=0
Ra8i4 a8i4 0 1e12
Ca12r4 a12r4 0 1 ic=0
Ra12r4 a12r4 0 1e12
Ca12i4 a12i4 0 1 ic=0
Ra12i4 a12i4 0 1e12
B4r4 a4r4 0 I={-(((-0.045*(V(a4r4)))+(-0.16*(V(a4i3)-2*V(a4i4)+V(a4i5)))+(-0.01*((V(a4r4))*(V(a4r4))+(V(a4i4))*(V(a4i4))+(V(a8r4))*(V(a8r4))+(V(a8i4))*(V(a8i4))+(V(a12r4))*(V(a12r4))+(V(a12i4))*(V(a12i4)))*(V(a4r4)))))}
B4i4 a4i4 0 I={-(((-0.045*(V(a4i4)))+(0.16*(V(a4r3)-2*V(a4r4)+V(a4r5)))+(-0.01*((V(a4r4))*(V(a4r4))+(V(a4i4))*(V(a4i4))+(V(a8r4))*(V(a8r4))+(V(a8i4))*(V(a8i4))+(V(a12r4))*(V(a12r4))+(V(a12i4))*(V(a12i4)))*(V(a4i4)))))}
B8r4 a8r4 0 I={-(((-0.0486*(V(a8r4)))+(0*(V(a8i4)))+(-0.1472*(V(a8i3)-2*V(a8i4)+V(a8i5)))+(-0.01*((V(a4r4))*(V(a4r4))+(V(a4i4))*(V(a4i4))+(V(a8r4))*(V(a8r4))+(V(a8i4))*(V(a8i4))+(V(a12r4))*(V(a12r4))+(V(a12i4))*(V(a12i4)))*(V(a8r4)))+(0.06*((((V(a4r4))*(V(a4r4))-(V(a4i4))*(V(a4i4))))*cos((0.628571428571+0.04*time))+((2*(V(a4r4))*(V(a4i4))))*sin((0.628571428571+0.04*time))))))}
B8i4 a8i4 0 I={-(((-0.0486*(V(a8i4)))+(-0*(V(a8r4)))+(0.1472*(V(a8r3)-2*V(a8r4)+V(a8r5)))+(-0.01*((V(a4r4))*(V(a4r4))+(V(a4i4))*(V(a4i4))+(V(a8r4))*(V(a8r4))+(V(a8i4))*(V(a8i4))+(V(a12r4))*(V(a12r4))+(V(a12i4))*(V(a12i4)))*(V(a8i4)))+(0.06*(((2*(V(a4r4))*(V(a4i4))))*cos((0.628571428571+0.04*time))-(((V(a4r4))*(V(a4r4))-(V(a4i4))*(V(a4i4))))*sin((0.628571428571+0.04*time))))))}
B12r4 a12r4 0 I={-(((-0.0522*(V(a12r4)))+(0*(V(a12i4)))+(-0.1344*(V(a12i3)-2*V(a12i4)+V(a12i5)))+(-0.01*((V(a4r4))*(V(a4r4))+(V(a4i4))*(V(a4i4))+(V(a8r4))*(V(a8r4))+(V(a8i4))*(V(a8i4))+(V(a12r4))*(V(a12r4))+(V(a12i4))*(V(a12i4)))*(V(a12r4)))+(0.075*((((V(a4r4))*(V(a8r4))-(V(a4i4))*(V(a8i4))))*cos((0.8+-0.06*time))+(((V(a4r4))*(V(a8i4))+(V(a4i4))*(V(a8r4))))*sin((0.8+-0.06*time))))))}
B12i4 a12i4 0 I={-(((-0.0522*(V(a12i4)))+(-0*(V(a12r4)))+(0.1344*(V(a12r3)-2*V(a12r4)+V(a12r5)))+(-0.01*((V(a4r4))*(V(a4r4))+(V(a4i4))*(V(a4i4))+(V(a8r4))*(V(a8r4))+(V(a8i4))*(V(a8i4))+(V(a12r4))*(V(a12r4))+(V(a12i4))*(V(a12i4)))*(V(a12i4)))+(0.075*((((V(a4r4))*(V(a8i4))+(V(a4i4))*(V(a8r4))))*cos((0.8+-0.06*time))-(((V(a4r4))*(V(a8r4))-(V(a4i4))*(V(a8i4))))*sin((0.8+-0.06*time))))))}
Idrive4_4 a4r4 0 PWL(0 0 11.52 -1.66758941884e-12 78.72 -1.66758941884e-12 96 0)

Ca4r5 a4r5 0 1 ic=0
Ra4r5 a4r5 0 1e12
Ca4i5 a4i5 0 1 ic=0
Ra4i5 a4i5 0 1e12
Ca8r5 a8r5 0 1 ic=0
Ra8r5 a8r5 0 1e12
Ca8i5 a8i5 0 1 ic=0
Ra8i5 a8i5 0 1e12
Ca12r5 a12r5 0 1 ic=0
Ra12r5 a12r5 0 1e12
Ca12i5 a12i5 0 1 ic=0
Ra12i5 a12i5 0 1e12
B4r5 a4r5 0 I={-(((-0.045*(V(a4r5)))+(-0.16*(V(a4i4)-2*V(a4i5)+V(a4i6)))+(-0.01*((V(a4r5))*(V(a4r5))+(V(a4i5))*(V(a4i5))+(V(a8r5))*(V(a8r5))+(V(a8i5))*(V(a8i5))+(V(a12r5))*(V(a12r5))+(V(a12i5))*(V(a12i5)))*(V(a4r5)))))}
B4i5 a4i5 0 I={-(((-0.045*(V(a4i5)))+(0.16*(V(a4r4)-2*V(a4r5)+V(a4r6)))+(-0.01*((V(a4r5))*(V(a4r5))+(V(a4i5))*(V(a4i5))+(V(a8r5))*(V(a8r5))+(V(a8i5))*(V(a8i5))+(V(a12r5))*(V(a12r5))+(V(a12i5))*(V(a12i5)))*(V(a4i5)))))}
B8r5 a8r5 0 I={-(((-0.0486*(V(a8r5)))+(0*(V(a8i5)))+(-0.1472*(V(a8i4)-2*V(a8i5)+V(a8i6)))+(-0.01*((V(a4r5))*(V(a4r5))+(V(a4i5))*(V(a4i5))+(V(a8r5))*(V(a8r5))+(V(a8i5))*(V(a8i5))+(V(a12r5))*(V(a12r5))+(V(a12i5))*(V(a12i5)))*(V(a8r5)))+(0.06*((((V(a4r5))*(V(a4r5))-(V(a4i5))*(V(a4i5))))*cos((0.785714285714+0.04*time))+((2*(V(a4r5))*(V(a4i5))))*sin((0.785714285714+0.04*time))))))}
B8i5 a8i5 0 I={-(((-0.0486*(V(a8i5)))+(-0*(V(a8r5)))+(0.1472*(V(a8r4)-2*V(a8r5)+V(a8r6)))+(-0.01*((V(a4r5))*(V(a4r5))+(V(a4i5))*(V(a4i5))+(V(a8r5))*(V(a8r5))+(V(a8i5))*(V(a8i5))+(V(a12r5))*(V(a12r5))+(V(a12i5))*(V(a12i5)))*(V(a8i5)))+(0.06*(((2*(V(a4r5))*(V(a4i5))))*cos((0.785714285714+0.04*time))-(((V(a4r5))*(V(a4r5))-(V(a4i5))*(V(a4i5))))*sin((0.785714285714+0.04*time))))))}
B12r5 a12r5 0 I={-(((-0.0522*(V(a12r5)))+(0*(V(a12i5)))+(-0.1344*(V(a12i4)-2*V(a12i5)+V(a12i6)))+(-0.01*((V(a4r5))*(V(a4r5))+(V(a4i5))*(V(a4i5))+(V(a8r5))*(V(a8r5))+(V(a8i5))*(V(a8i5))+(V(a12r5))*(V(a12r5))+(V(a12i5))*(V(a12i5)))*(V(a12r5)))+(0.075*((((V(a4r5))*(V(a8r5))-(V(a4i5))*(V(a8i5))))*cos((1+-0.06*time))+(((V(a4r5))*(V(a8i5))+(V(a4i5))*(V(a8r5))))*sin((1+-0.06*time))))))}
B12i5 a12i5 0 I={-(((-0.0522*(V(a12i5)))+(-0*(V(a12r5)))+(0.1344*(V(a12r4)-2*V(a12r5)+V(a12r6)))+(-0.01*((V(a4r5))*(V(a4r5))+(V(a4i5))*(V(a4i5))+(V(a8r5))*(V(a8r5))+(V(a8i5))*(V(a8i5))+(V(a12r5))*(V(a12r5))+(V(a12i5))*(V(a12i5)))*(V(a12i5)))+(0.075*((((V(a4r5))*(V(a8i5))+(V(a4i5))*(V(a8r5))))*cos((1+-0.06*time))-(((V(a4r5))*(V(a8r5))-(V(a4i5))*(V(a8i5))))*sin((1+-0.06*time))))))}

Ca4r6 a4r6 0 1 ic=0
Ra4r6 a4r6 0 1e12
Ca4i6 a4i6 0 1 ic=0
Ra4i6 a4i6 0 1e12
Ca8r6 a8r6 0 1 ic=0
Ra8r6 a8r6 0 1e12
Ca8i6 a8i6 0 1 ic=0
Ra8i6 a8i6 0 1e12
Ca12r6 a12r6 0 1 ic=0
Ra12r6 a12r6 0 1e12
Ca12i6 a12i6 0 1 ic=0
Ra12i6 a12i6 0 1e12
B4r6 a4r6 0 I={-(((-0.045*(V(a4r6)))+(-0.16*(V(a4i5)-2*V(a4i6)+V(a4i7)))+(-0.01*((V(a4r6))*(V(a4r6))+(V(a4i6))*(V(a4i6))+(V(a8r6))*(V(a8r6))+(V(a8i6))*(V(a8i6))+(V(a12r6))*(V(a12r6))+(V(a12i6))*(V(a12i6)))*(V(a4r6)))))}
B4i6 a4i6 0 I={-(((-0.045*(V(a4i6)))+(0.16*(V(a4r5)-2*V(a4r6)+V(a4r7)))+(-0.01*((V(a4r6))*(V(a4r6))+(V(a4i6))*(V(a4i6))+(V(a8r6))*(V(a8r6))+(V(a8i6))*(V(a8i6))+(V(a12r6))*(V(a12r6))+(V(a12i6))*(V(a12i6)))*(V(a4i6)))))}
B8r6 a8r6 0 I={-(((-0.0486*(V(a8r6)))+(0*(V(a8i6)))+(-0.1472*(V(a8i5)-2*V(a8i6)+V(a8i7)))+(-0.01*((V(a4r6))*(V(a4r6))+(V(a4i6))*(V(a4i6))+(V(a8r6))*(V(a8r6))+(V(a8i6))*(V(a8i6))+(V(a12r6))*(V(a12r6))+(V(a12i6))*(V(a12i6)))*(V(a8r6)))+(0.06*((((V(a4r6))*(V(a4r6))-(V(a4i6))*(V(a4i6))))*cos((0.942857142857+0.04*time))+((2*(V(a4r6))*(V(a4i6))))*sin((0.942857142857+0.04*time))))))}
B8i6 a8i6 0 I={-(((-0.0486*(V(a8i6)))+(-0*(V(a8r6)))+(0.1472*(V(a8r5)-2*V(a8r6)+V(a8r7)))+(-0.01*((V(a4r6))*(V(a4r6))+(V(a4i6))*(V(a4i6))+(V(a8r6))*(V(a8r6))+(V(a8i6))*(V(a8i6))+(V(a12r6))*(V(a12r6))+(V(a12i6))*(V(a12i6)))*(V(a8i6)))+(0.06*(((2*(V(a4r6))*(V(a4i6))))*cos((0.942857142857+0.04*time))-(((V(a4r6))*(V(a4r6))-(V(a4i6))*(V(a4i6))))*sin((0.942857142857+0.04*time))))))}
B12r6 a12r6 0 I={-(((-0.0522*(V(a12r6)))+(0*(V(a12i6)))+(-0.1344*(V(a12i5)-2*V(a12i6)+V(a12i7)))+(-0.01*((V(a4r6))*(V(a4r6))+(V(a4i6))*(V(a4i6))+(V(a8r6))*(V(a8r6))+(V(a8i6))*(V(a8i6))+(V(a12r6))*(V(a12r6))+(V(a12i6))*(V(a12i6)))*(V(a12r6)))+(0.075*((((V(a4r6))*(V(a8r6))-(V(a4i6))*(V(a8i6))))*cos((1.2+-0.06*time))+(((V(a4r6))*(V(a8i6))+(V(a4i6))*(V(a8r6))))*sin((1.2+-0.06*time))))))}
B12i6 a12i6 0 I={-(((-0.0522*(V(a12i6)))+(-0*(V(a12r6)))+(0.1344*(V(a12r5)-2*V(a12r6)+V(a12r7)))+(-0.01*((V(a4r6))*(V(a4r6))+(V(a4i6))*(V(a4i6))+(V(a8r6))*(V(a8r6))+(V(a8i6))*(V(a8i6))+(V(a12r6))*(V(a12r6))+(V(a12i6))*(V(a12i6)))*(V(a12i6)))+(0.075*((((V(a4r6))*(V(a8i6))+(V(a4i6))*(V(a8r6))))*cos((1.2+-0.06*time))-(((V(a4r6))*(V(a8r6))-(V(a4i6))*(V(a8i6))))*sin((1.2+-0.06*time))))))}

Ca4r7 a4r7 0 1 ic=0
Ra4r7 a4r7 0 1e12
Ca4i7 a4i7 0 1 ic=0
Ra4i7 a4i7 0 1e12
Ca8r7 a8r7 0 1 ic=0
Ra8r7 a8r7 0 1e12
Ca8i7 a8i7 0 1 ic=0
Ra8i7 a8i7 0 1e12
Ca12r7 a12r7 0 1 ic=0
Ra12r7 a12r7 0 1e12
Ca12i7 a12i7 0 1 ic=0
Ra12i7 a12i7 0 1e12
B4r7 a4r7 0 I={-(((-0.045*(V(a4r7)))+(-0.16*(V(a4i6)-V(a4i7)))+(-0.01*((V(a4r7))*(V(a4r7))+(V(a4i7))*(V(a4i7))+(V(a8r7))*(V(a8r7))+(V(a8i7))*(V(a8i7))+(V(a12r7))*(V(a12r7))+(V(a12i7))*(V(a12i7)))*(V(a4r7)))))}
B4i7 a4i7 0 I={-(((-0.045*(V(a4i7)))+(0.16*(V(a4r6)-V(a4r7)))+(-0.01*((V(a4r7))*(V(a4r7))+(V(a4i7))*(V(a4i7))+(V(a8r7))*(V(a8r7))+(V(a8i7))*(V(a8i7))+(V(a12r7))*(V(a12r7))+(V(a12i7))*(V(a12i7)))*(V(a4i7)))))}
B8r7 a8r7 0 I={-(((-0.0486*(V(a8r7)))+(0*(V(a8i7)))+(-0.1472*(V(a8i6)-V(a8i7)))+(-0.01*((V(a4r7))*(V(a4r7))+(V(a4i7))*(V(a4i7))+(V(a8r7))*(V(a8r7))+(V(a8i7))*(V(a8i7))+(V(a12r7))*(V(a12r7))+(V(a12i7))*(V(a12i7)))*(V(a8r7)))+(0.06*((((V(a4r7))*(V(a4r7))-(V(a4i7))*(V(a4i7))))*cos((1.1+0.04*time))+((2*(V(a4r7))*(V(a4i7))))*sin((1.1+0.04*time))))))}
B8i7 a8i7 0 I={-(((-0.0486*(V(a8i7)))+(-0*(V(a8r7)))+(0.1472*(V(a8r6)-V(a8r7)))+(-0.01*((V(a4r7))*(V(a4r7))+(V(a4i7))*(V(a4i7))+(V(a8r7))*(V(a8r7))+(V(a8i7))*(V(a8i7))+(V(a12r7))*(V(a12r7))+(V(a12i7))*(V(a12i7)))*(V(a8i7)))+(0.06*(((2*(V(a4r7))*(V(a4i7))))*cos((1.1+0.04*time))-(((V(a4r7))*(V(a4r7))-(V(a4i7))*(V(a4i7))))*sin((1.1+0.04*time))))))}
B12r7 a12r7 0 I={-(((-0.0522*(V(a12r7)))+(0*(V(a12i7)))+(-0.1344*(V(a12i6)-V(a12i7)))+(-0.01*((V(a4r7))*(V(a4r7))+(V(a4i7))*(V(a4i7))+(V(a8r7))*(V(a8r7))+(V(a8i7))*(V(a8i7))+(V(a12r7))*(V(a12r7))+(V(a12i7))*(V(a12i7)))*(V(a12r7)))+(0.075*((((V(a4r7))*(V(a8r7))-(V(a4i7))*(V(a8i7))))*cos((1.4+-0.06*time))+(((V(a4r7))*(V(a8i7))+(V(a4i7))*(V(a8r7))))*sin((1.4+-0.06*time))))))}
B12i7 a12i7 0 I={-(((-0.0522*(V(a12i7)))+(-0*(V(a12r7)))+(0.1344*(V(a12r6)-V(a12r7)))+(-0.01*((V(a4r7))*(V(a4r7))+(V(a4i7))*(V(a4i7))+(V(a8r7))*(V(a8r7))+(V(a8i7))*(V(a8i7))+(V(a12r7))*(V(a12r7))+(V(a12i7))*(V(a12i7)))*(V(a12i7)))+(0.075*((((V(a4r7))*(V(a8i7))+(V(a4i7))*(V(a8r7))))*cos((1.4+-0.06*time))-(((V(a4r7))*(V(a8r7))-(V(a4i7))*(V(a8i7))))*sin((1.4+-0.06*time))))))}

Bobs4r obs4r 0 V={(1.34233894807e-05*V(a4r0)+0.00020804707928*V(a4r1)+0.00211513487207*V(a4r2)+0.0141055985085*V(a4r3)+0.0617052308609*V(a4r4)+0.177063667413*V(a4r5)+0.333283596777*V(a4r6)+0.411505301101*V(a4r7))}
Bobs4i obs4i 0 V={(1.34233894807e-05*V(a4i0)+0.00020804707928*V(a4i1)+0.00211513487207*V(a4i2)+0.0141055985085*V(a4i3)+0.0617052308609*V(a4i4)+0.177063667413*V(a4i5)+0.333283596777*V(a4i6)+0.411505301101*V(a4i7))}
Bobs8r obs8r 0 V={(1.34233894807e-05*V(a8r0)+0.00020804707928*V(a8r1)+0.00211513487207*V(a8r2)+0.0141055985085*V(a8r3)+0.0617052308609*V(a8r4)+0.177063667413*V(a8r5)+0.333283596777*V(a8r6)+0.411505301101*V(a8r7))}
Bobs8i obs8i 0 V={(1.34233894807e-05*V(a8i0)+0.00020804707928*V(a8i1)+0.00211513487207*V(a8i2)+0.0141055985085*V(a8i3)+0.0617052308609*V(a8i4)+0.177063667413*V(a8i5)+0.333283596777*V(a8i6)+0.411505301101*V(a8i7))}
Bobs12r obs12r 0 V={(1.34233894807e-05*V(a12r0)+0.00020804707928*V(a12r1)+0.00211513487207*V(a12r2)+0.0141055985085*V(a12r3)+0.0617052308609*V(a12r4)+0.177063667413*V(a12r5)+0.333283596777*V(a12r6)+0.411505301101*V(a12r7))}
Bobs12i obs12i 0 V={(1.34233894807e-05*V(a12i0)+0.00020804707928*V(a12i1)+0.00211513487207*V(a12i2)+0.0141055985085*V(a12i3)+0.0617052308609*V(a12i4)+0.177063667413*V(a12i5)+0.333283596777*V(a12i6)+0.411505301101*V(a12i7))}

.control
set noaskquit
set filetype=ascii
tran 0.04 96 0 0.04 uic
wrdata lumped_equivalent_control_tran.csv v(obs4r) v(obs4i) v(obs8r) v(obs8i) v(obs12r) v(obs12i) v(a4r0) v(a4i0) v(a8r0) v(a8i0) v(a12r0) v(a12i0) v(a4r1) v(a4i1) v(a8r1) v(a8i1) v(a12r1) v(a12i1) v(a4r2) v(a4i2) v(a8r2) v(a8i2) v(a12r2) v(a12i2) v(a4r3) v(a4i3) v(a8r3) v(a8i3) v(a12r3) v(a12i3) v(a4r4) v(a4i4) v(a8r4) v(a8i4) v(a12r4) v(a12i4) v(a4r5) v(a4i5) v(a8r5) v(a8i5) v(a12r5) v(a12i5) v(a4r6) v(a4i6) v(a8r6) v(a8i6) v(a12r6) v(a12i6) v(a4r7) v(a4i7) v(a8r7) v(a8i7) v(a12r7) v(a12i7)
quit
.endc
.end

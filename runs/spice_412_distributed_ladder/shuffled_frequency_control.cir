* shuffled_frequency_control
* Normalized distributed envelope ladder for 4->8->12 phase matching.
* topology=shuffled_frequency_control role=control
* Source-only discovery rule: direct 8 and direct 12 drives are absent unless role=ceiling_reference.
.options reltol=1e-4 abstol=1e-8 chgtol=1e-12 method=gear maxord=2
.param tstep=0.04
.param tstop=96

Ca4r0 a4r0 0 1 ic=0
Ra4r0 a4r0 0 1e12
Ca4i0 a4i0 0 1 ic=0
Ra4i0 a4i0 0 1e12
Ca8r0 a8r0 0 1 ic=0
Ra8r0 a8r0 0 1e12
Ca8i0 a8i0 0 1 ic=0
Ra8i0 a8i0 0 1e12
Ca12r0 a12r0 0 1 ic=0
Ra12r0 a12r0 0 1e12
Ca12i0 a12i0 0 1 ic=0
Ra12i0 a12i0 0 1e12
B4r0 a4r0 0 I={-(((-0.045*(V(a4r0)))+(-0.16*(V(a4i1)-V(a4i0)))+(-0.01*((V(a4r0))*(V(a4r0))+(V(a4i0))*(V(a4i0))+(V(a8r0))*(V(a8r0))+(V(a8i0))*(V(a8i0))+(V(a12r0))*(V(a12r0))+(V(a12i0))*(V(a12i0)))*(V(a4r0)))))}
B4i0 a4i0 0 I={-(((-0.045*(V(a4i0)))+(0.16*(V(a4r1)-V(a4r0)))+(-0.01*((V(a4r0))*(V(a4r0))+(V(a4i0))*(V(a4i0))+(V(a8r0))*(V(a8r0))+(V(a8i0))*(V(a8i0))+(V(a12r0))*(V(a12r0))+(V(a12i0))*(V(a12i0)))*(V(a4i0)))))}
B8r0 a8r0 0 I={-(((-0.0486*(V(a8r0)))+(0*(V(a8i0)))+(-0.1472*(V(a8i1)-V(a8i0)))+(-0.01*((V(a4r0))*(V(a4r0))+(V(a4i0))*(V(a4i0))+(V(a8r0))*(V(a8r0))+(V(a8i0))*(V(a8i0))+(V(a12r0))*(V(a12r0))+(V(a12i0))*(V(a12i0)))*(V(a8r0)))+(0.13175*((((V(a4r0))*(V(a4r0))-(V(a4i0))*(V(a4i0))))*cos((0+1.93*time))+((2*(V(a4r0))*(V(a4i0))))*sin((0+1.93*time))))))}
B8i0 a8i0 0 I={-(((-0.0486*(V(a8i0)))+(-0*(V(a8r0)))+(0.1472*(V(a8r1)-V(a8r0)))+(-0.01*((V(a4r0))*(V(a4r0))+(V(a4i0))*(V(a4i0))+(V(a8r0))*(V(a8r0))+(V(a8i0))*(V(a8i0))+(V(a12r0))*(V(a12r0))+(V(a12i0))*(V(a12i0)))*(V(a8i0)))+(0.13175*(((2*(V(a4r0))*(V(a4i0))))*cos((0+1.93*time))-(((V(a4r0))*(V(a4r0))-(V(a4i0))*(V(a4i0))))*sin((0+1.93*time))))))}
B12r0 a12r0 0 I={-(((-0.0522*(V(a12r0)))+(0*(V(a12i0)))+(-0.1344*(V(a12i1)-V(a12i0)))+(-0.01*((V(a4r0))*(V(a4r0))+(V(a4i0))*(V(a4i0))+(V(a8r0))*(V(a8r0))+(V(a8i0))*(V(a8i0))+(V(a12r0))*(V(a12r0))+(V(a12i0))*(V(a12i0)))*(V(a12r0)))+(0.17825*((((V(a4r0))*(V(a8r0))-(V(a4i0))*(V(a8i0))))*cos((0+-3.71*time))+(((V(a4r0))*(V(a8i0))+(V(a4i0))*(V(a8r0))))*sin((0+-3.71*time))))))}
B12i0 a12i0 0 I={-(((-0.0522*(V(a12i0)))+(-0*(V(a12r0)))+(0.1344*(V(a12r1)-V(a12r0)))+(-0.01*((V(a4r0))*(V(a4r0))+(V(a4i0))*(V(a4i0))+(V(a8r0))*(V(a8r0))+(V(a8i0))*(V(a8i0))+(V(a12r0))*(V(a12r0))+(V(a12i0))*(V(a12i0)))*(V(a12i0)))+(0.17825*((((V(a4r0))*(V(a8i0))+(V(a4i0))*(V(a8r0))))*cos((0+-3.71*time))-(((V(a4r0))*(V(a8r0))-(V(a4i0))*(V(a8i0))))*sin((0+-3.71*time))))))}
Idrive4_0 a4r0 0 PWL(0 0 11.52 -0.2 78.72 -0.2 96 0)

Ca4r1 a4r1 0 1 ic=0
Ra4r1 a4r1 0 1e12
Ca4i1 a4i1 0 1 ic=0
Ra4i1 a4i1 0 1e12
Ca8r1 a8r1 0 1 ic=0
Ra8r1 a8r1 0 1e12
Ca8i1 a8i1 0 1 ic=0
Ra8i1 a8i1 0 1e12
Ca12r1 a12r1 0 1 ic=0
Ra12r1 a12r1 0 1e12
Ca12i1 a12i1 0 1 ic=0
Ra12i1 a12i1 0 1e12
B4r1 a4r1 0 I={-(((-0.045*(V(a4r1)))+(-0.16*(V(a4i0)-2*V(a4i1)+V(a4i2)))+(-0.01*((V(a4r1))*(V(a4r1))+(V(a4i1))*(V(a4i1))+(V(a8r1))*(V(a8r1))+(V(a8i1))*(V(a8i1))+(V(a12r1))*(V(a12r1))+(V(a12i1))*(V(a12i1)))*(V(a4r1)))))}
B4i1 a4i1 0 I={-(((-0.045*(V(a4i1)))+(0.16*(V(a4r0)-2*V(a4r1)+V(a4r2)))+(-0.01*((V(a4r1))*(V(a4r1))+(V(a4i1))*(V(a4i1))+(V(a8r1))*(V(a8r1))+(V(a8i1))*(V(a8i1))+(V(a12r1))*(V(a12r1))+(V(a12i1))*(V(a12i1)))*(V(a4i1)))))}
B8r1 a8r1 0 I={-(((-0.0486*(V(a8r1)))+(0*(V(a8i1)))+(-0.1472*(V(a8i0)-2*V(a8i1)+V(a8i2)))+(-0.01*((V(a4r1))*(V(a4r1))+(V(a4i1))*(V(a4i1))+(V(a8r1))*(V(a8r1))+(V(a8i1))*(V(a8i1))+(V(a12r1))*(V(a12r1))+(V(a12i1))*(V(a12i1)))*(V(a8r1)))+(0.13175*((((V(a4r1))*(V(a4r1))-(V(a4i1))*(V(a4i1))))*cos((0.774193548387+1.93*time))+((2*(V(a4r1))*(V(a4i1))))*sin((0.774193548387+1.93*time))))))}
B8i1 a8i1 0 I={-(((-0.0486*(V(a8i1)))+(-0*(V(a8r1)))+(0.1472*(V(a8r0)-2*V(a8r1)+V(a8r2)))+(-0.01*((V(a4r1))*(V(a4r1))+(V(a4i1))*(V(a4i1))+(V(a8r1))*(V(a8r1))+(V(a8i1))*(V(a8i1))+(V(a12r1))*(V(a12r1))+(V(a12i1))*(V(a12i1)))*(V(a8i1)))+(0.13175*(((2*(V(a4r1))*(V(a4i1))))*cos((0.774193548387+1.93*time))-(((V(a4r1))*(V(a4r1))-(V(a4i1))*(V(a4i1))))*sin((0.774193548387+1.93*time))))))}
B12r1 a12r1 0 I={-(((-0.0522*(V(a12r1)))+(0*(V(a12i1)))+(-0.1344*(V(a12i0)-2*V(a12i1)+V(a12i2)))+(-0.01*((V(a4r1))*(V(a4r1))+(V(a4i1))*(V(a4i1))+(V(a8r1))*(V(a8r1))+(V(a8i1))*(V(a8i1))+(V(a12r1))*(V(a12r1))+(V(a12i1))*(V(a12i1)))*(V(a12r1)))+(0.17825*((((V(a4r1))*(V(a8r1))-(V(a4i1))*(V(a8i1))))*cos((-0.774193548387+-3.71*time))+(((V(a4r1))*(V(a8i1))+(V(a4i1))*(V(a8r1))))*sin((-0.774193548387+-3.71*time))))))}
B12i1 a12i1 0 I={-(((-0.0522*(V(a12i1)))+(-0*(V(a12r1)))+(0.1344*(V(a12r0)-2*V(a12r1)+V(a12r2)))+(-0.01*((V(a4r1))*(V(a4r1))+(V(a4i1))*(V(a4i1))+(V(a8r1))*(V(a8r1))+(V(a8i1))*(V(a8i1))+(V(a12r1))*(V(a12r1))+(V(a12i1))*(V(a12i1)))*(V(a12i1)))+(0.17825*((((V(a4r1))*(V(a8i1))+(V(a4i1))*(V(a8r1))))*cos((-0.774193548387+-3.71*time))-(((V(a4r1))*(V(a8r1))-(V(a4i1))*(V(a8i1))))*sin((-0.774193548387+-3.71*time))))))}
Idrive4_1 a4r1 0 PWL(0 0 11.52 -0.184384239993 78.72 -0.184384239993 96 0)

Ca4r2 a4r2 0 1 ic=0
Ra4r2 a4r2 0 1e12
Ca4i2 a4i2 0 1 ic=0
Ra4i2 a4i2 0 1e12
Ca8r2 a8r2 0 1 ic=0
Ra8r2 a8r2 0 1e12
Ca8i2 a8i2 0 1 ic=0
Ra8i2 a8i2 0 1e12
Ca12r2 a12r2 0 1 ic=0
Ra12r2 a12r2 0 1e12
Ca12i2 a12i2 0 1 ic=0
Ra12i2 a12i2 0 1e12
B4r2 a4r2 0 I={-(((-0.045*(V(a4r2)))+(-0.16*(V(a4i1)-2*V(a4i2)+V(a4i3)))+(-0.01*((V(a4r2))*(V(a4r2))+(V(a4i2))*(V(a4i2))+(V(a8r2))*(V(a8r2))+(V(a8i2))*(V(a8i2))+(V(a12r2))*(V(a12r2))+(V(a12i2))*(V(a12i2)))*(V(a4r2)))))}
B4i2 a4i2 0 I={-(((-0.045*(V(a4i2)))+(0.16*(V(a4r1)-2*V(a4r2)+V(a4r3)))+(-0.01*((V(a4r2))*(V(a4r2))+(V(a4i2))*(V(a4i2))+(V(a8r2))*(V(a8r2))+(V(a8i2))*(V(a8i2))+(V(a12r2))*(V(a12r2))+(V(a12i2))*(V(a12i2)))*(V(a4i2)))))}
B8r2 a8r2 0 I={-(((-0.0486*(V(a8r2)))+(0*(V(a8i2)))+(-0.1472*(V(a8i1)-2*V(a8i2)+V(a8i3)))+(-0.01*((V(a4r2))*(V(a4r2))+(V(a4i2))*(V(a4i2))+(V(a8r2))*(V(a8r2))+(V(a8i2))*(V(a8i2))+(V(a12r2))*(V(a12r2))+(V(a12i2))*(V(a12i2)))*(V(a8r2)))+(0.13175*((((V(a4r2))*(V(a4r2))-(V(a4i2))*(V(a4i2))))*cos((1.54838709677+1.93*time))+((2*(V(a4r2))*(V(a4i2))))*sin((1.54838709677+1.93*time))))))}
B8i2 a8i2 0 I={-(((-0.0486*(V(a8i2)))+(-0*(V(a8r2)))+(0.1472*(V(a8r1)-2*V(a8r2)+V(a8r3)))+(-0.01*((V(a4r2))*(V(a4r2))+(V(a4i2))*(V(a4i2))+(V(a8r2))*(V(a8r2))+(V(a8i2))*(V(a8i2))+(V(a12r2))*(V(a12r2))+(V(a12i2))*(V(a12i2)))*(V(a8i2)))+(0.13175*(((2*(V(a4r2))*(V(a4i2))))*cos((1.54838709677+1.93*time))-(((V(a4r2))*(V(a4r2))-(V(a4i2))*(V(a4i2))))*sin((1.54838709677+1.93*time))))))}
B12r2 a12r2 0 I={-(((-0.0522*(V(a12r2)))+(0*(V(a12i2)))+(-0.1344*(V(a12i1)-2*V(a12i2)+V(a12i3)))+(-0.01*((V(a4r2))*(V(a4r2))+(V(a4i2))*(V(a4i2))+(V(a8r2))*(V(a8r2))+(V(a8i2))*(V(a8i2))+(V(a12r2))*(V(a12r2))+(V(a12i2))*(V(a12i2)))*(V(a12r2)))+(0.17825*((((V(a4r2))*(V(a8r2))-(V(a4i2))*(V(a8i2))))*cos((-1.54838709677+-3.71*time))+(((V(a4r2))*(V(a8i2))+(V(a4i2))*(V(a8r2))))*sin((-1.54838709677+-3.71*time))))))}
B12i2 a12i2 0 I={-(((-0.0522*(V(a12i2)))+(-0*(V(a12r2)))+(0.1344*(V(a12r1)-2*V(a12r2)+V(a12r3)))+(-0.01*((V(a4r2))*(V(a4r2))+(V(a4i2))*(V(a4i2))+(V(a8r2))*(V(a8r2))+(V(a8i2))*(V(a8i2))+(V(a12r2))*(V(a12r2))+(V(a12i2))*(V(a12i2)))*(V(a12i2)))+(0.17825*((((V(a4r2))*(V(a8i2))+(V(a4i2))*(V(a8r2))))*cos((-1.54838709677+-3.71*time))-(((V(a4r2))*(V(a8r2))-(V(a4i2))*(V(a8i2))))*sin((-1.54838709677+-3.71*time))))))}
Idrive4_2 a4r2 0 PWL(0 0 11.52 -0.144479158392 78.72 -0.144479158392 96 0)

Ca4r3 a4r3 0 1 ic=0
Ra4r3 a4r3 0 1e12
Ca4i3 a4i3 0 1 ic=0
Ra4i3 a4i3 0 1e12
Ca8r3 a8r3 0 1 ic=0
Ra8r3 a8r3 0 1e12
Ca8i3 a8i3 0 1 ic=0
Ra8i3 a8i3 0 1e12
Ca12r3 a12r3 0 1 ic=0
Ra12r3 a12r3 0 1e12
Ca12i3 a12i3 0 1 ic=0
Ra12i3 a12i3 0 1e12
B4r3 a4r3 0 I={-(((-0.045*(V(a4r3)))+(-0.16*(V(a4i2)-2*V(a4i3)+V(a4i4)))+(-0.01*((V(a4r3))*(V(a4r3))+(V(a4i3))*(V(a4i3))+(V(a8r3))*(V(a8r3))+(V(a8i3))*(V(a8i3))+(V(a12r3))*(V(a12r3))+(V(a12i3))*(V(a12i3)))*(V(a4r3)))))}
B4i3 a4i3 0 I={-(((-0.045*(V(a4i3)))+(0.16*(V(a4r2)-2*V(a4r3)+V(a4r4)))+(-0.01*((V(a4r3))*(V(a4r3))+(V(a4i3))*(V(a4i3))+(V(a8r3))*(V(a8r3))+(V(a8i3))*(V(a8i3))+(V(a12r3))*(V(a12r3))+(V(a12i3))*(V(a12i3)))*(V(a4i3)))))}
B8r3 a8r3 0 I={-(((-0.0486*(V(a8r3)))+(0*(V(a8i3)))+(-0.1472*(V(a8i2)-2*V(a8i3)+V(a8i4)))+(-0.01*((V(a4r3))*(V(a4r3))+(V(a4i3))*(V(a4i3))+(V(a8r3))*(V(a8r3))+(V(a8i3))*(V(a8i3))+(V(a12r3))*(V(a12r3))+(V(a12i3))*(V(a12i3)))*(V(a8r3)))+(0.13175*((((V(a4r3))*(V(a4r3))-(V(a4i3))*(V(a4i3))))*cos((2.32258064516+1.93*time))+((2*(V(a4r3))*(V(a4i3))))*sin((2.32258064516+1.93*time))))))}
B8i3 a8i3 0 I={-(((-0.0486*(V(a8i3)))+(-0*(V(a8r3)))+(0.1472*(V(a8r2)-2*V(a8r3)+V(a8r4)))+(-0.01*((V(a4r3))*(V(a4r3))+(V(a4i3))*(V(a4i3))+(V(a8r3))*(V(a8r3))+(V(a8i3))*(V(a8i3))+(V(a12r3))*(V(a12r3))+(V(a12i3))*(V(a12i3)))*(V(a8i3)))+(0.13175*(((2*(V(a4r3))*(V(a4i3))))*cos((2.32258064516+1.93*time))-(((V(a4r3))*(V(a4r3))-(V(a4i3))*(V(a4i3))))*sin((2.32258064516+1.93*time))))))}
B12r3 a12r3 0 I={-(((-0.0522*(V(a12r3)))+(0*(V(a12i3)))+(-0.1344*(V(a12i2)-2*V(a12i3)+V(a12i4)))+(-0.01*((V(a4r3))*(V(a4r3))+(V(a4i3))*(V(a4i3))+(V(a8r3))*(V(a8r3))+(V(a8i3))*(V(a8i3))+(V(a12r3))*(V(a12r3))+(V(a12i3))*(V(a12i3)))*(V(a12r3)))+(0.17825*((((V(a4r3))*(V(a8r3))-(V(a4i3))*(V(a8i3))))*cos((-2.32258064516+-3.71*time))+(((V(a4r3))*(V(a8i3))+(V(a4i3))*(V(a8r3))))*sin((-2.32258064516+-3.71*time))))))}
B12i3 a12i3 0 I={-(((-0.0522*(V(a12i3)))+(-0*(V(a12r3)))+(0.1344*(V(a12r2)-2*V(a12r3)+V(a12r4)))+(-0.01*((V(a4r3))*(V(a4r3))+(V(a4i3))*(V(a4i3))+(V(a8r3))*(V(a8r3))+(V(a8i3))*(V(a8i3))+(V(a12r3))*(V(a12r3))+(V(a12i3))*(V(a12i3)))*(V(a12i3)))+(0.17825*((((V(a4r3))*(V(a8i3))+(V(a4i3))*(V(a8r3))))*cos((-2.32258064516+-3.71*time))-(((V(a4r3))*(V(a8r3))-(V(a4i3))*(V(a8i3))))*sin((-2.32258064516+-3.71*time))))))}
Idrive4_3 a4r3 0 PWL(0 0 11.52 -0.0962219629877 78.72 -0.0962219629877 96 0)

Ca4r4 a4r4 0 1 ic=0
Ra4r4 a4r4 0 1e12
Ca4i4 a4i4 0 1 ic=0
Ra4i4 a4i4 0 1e12
Ca8r4 a8r4 0 1 ic=0
Ra8r4 a8r4 0 1e12
Ca8i4 a8i4 0 1 ic=0
Ra8i4 a8i4 0 1e12
Ca12r4 a12r4 0 1 ic=0
Ra12r4 a12r4 0 1e12
Ca12i4 a12i4 0 1 ic=0
Ra12i4 a12i4 0 1e12
B4r4 a4r4 0 I={-(((-0.045*(V(a4r4)))+(-0.16*(V(a4i3)-2*V(a4i4)+V(a4i5)))+(-0.01*((V(a4r4))*(V(a4r4))+(V(a4i4))*(V(a4i4))+(V(a8r4))*(V(a8r4))+(V(a8i4))*(V(a8i4))+(V(a12r4))*(V(a12r4))+(V(a12i4))*(V(a12i4)))*(V(a4r4)))))}
B4i4 a4i4 0 I={-(((-0.045*(V(a4i4)))+(0.16*(V(a4r3)-2*V(a4r4)+V(a4r5)))+(-0.01*((V(a4r4))*(V(a4r4))+(V(a4i4))*(V(a4i4))+(V(a8r4))*(V(a8r4))+(V(a8i4))*(V(a8i4))+(V(a12r4))*(V(a12r4))+(V(a12i4))*(V(a12i4)))*(V(a4i4)))))}
B8r4 a8r4 0 I={-(((-0.0486*(V(a8r4)))+(0*(V(a8i4)))+(-0.1472*(V(a8i3)-2*V(a8i4)+V(a8i5)))+(-0.01*((V(a4r4))*(V(a4r4))+(V(a4i4))*(V(a4i4))+(V(a8r4))*(V(a8r4))+(V(a8i4))*(V(a8i4))+(V(a12r4))*(V(a12r4))+(V(a12i4))*(V(a12i4)))*(V(a8r4)))+(0.13175*((((V(a4r4))*(V(a4r4))-(V(a4i4))*(V(a4i4))))*cos((3.09677419355+1.93*time))+((2*(V(a4r4))*(V(a4i4))))*sin((3.09677419355+1.93*time))))))}
B8i4 a8i4 0 I={-(((-0.0486*(V(a8i4)))+(-0*(V(a8r4)))+(0.1472*(V(a8r3)-2*V(a8r4)+V(a8r5)))+(-0.01*((V(a4r4))*(V(a4r4))+(V(a4i4))*(V(a4i4))+(V(a8r4))*(V(a8r4))+(V(a8i4))*(V(a8i4))+(V(a12r4))*(V(a12r4))+(V(a12i4))*(V(a12i4)))*(V(a8i4)))+(0.13175*(((2*(V(a4r4))*(V(a4i4))))*cos((3.09677419355+1.93*time))-(((V(a4r4))*(V(a4r4))-(V(a4i4))*(V(a4i4))))*sin((3.09677419355+1.93*time))))))}
B12r4 a12r4 0 I={-(((-0.0522*(V(a12r4)))+(0*(V(a12i4)))+(-0.1344*(V(a12i3)-2*V(a12i4)+V(a12i5)))+(-0.01*((V(a4r4))*(V(a4r4))+(V(a4i4))*(V(a4i4))+(V(a8r4))*(V(a8r4))+(V(a8i4))*(V(a8i4))+(V(a12r4))*(V(a12r4))+(V(a12i4))*(V(a12i4)))*(V(a12r4)))+(0.17825*((((V(a4r4))*(V(a8r4))-(V(a4i4))*(V(a8i4))))*cos((-3.09677419355+-3.71*time))+(((V(a4r4))*(V(a8i4))+(V(a4i4))*(V(a8r4))))*sin((-3.09677419355+-3.71*time))))))}
B12i4 a12i4 0 I={-(((-0.0522*(V(a12i4)))+(-0*(V(a12r4)))+(0.1344*(V(a12r3)-2*V(a12r4)+V(a12r5)))+(-0.01*((V(a4r4))*(V(a4r4))+(V(a4i4))*(V(a4i4))+(V(a8r4))*(V(a8r4))+(V(a8i4))*(V(a8i4))+(V(a12r4))*(V(a12r4))+(V(a12i4))*(V(a12i4)))*(V(a12i4)))+(0.17825*((((V(a4r4))*(V(a8i4))+(V(a4i4))*(V(a8r4))))*cos((-3.09677419355+-3.71*time))-(((V(a4r4))*(V(a8r4))-(V(a4i4))*(V(a8i4))))*sin((-3.09677419355+-3.71*time))))))}
Idrive4_4 a4r4 0 PWL(0 0 11.52 -0.0544666702006 78.72 -0.0544666702006 96 0)

Ca4r5 a4r5 0 1 ic=0
Ra4r5 a4r5 0 1e12
Ca4i5 a4i5 0 1 ic=0
Ra4i5 a4i5 0 1e12
Ca8r5 a8r5 0 1 ic=0
Ra8r5 a8r5 0 1e12
Ca8i5 a8i5 0 1 ic=0
Ra8i5 a8i5 0 1e12
Ca12r5 a12r5 0 1 ic=0
Ra12r5 a12r5 0 1e12
Ca12i5 a12i5 0 1 ic=0
Ra12i5 a12i5 0 1e12
B4r5 a4r5 0 I={-(((-0.045*(V(a4r5)))+(-0.16*(V(a4i4)-2*V(a4i5)+V(a4i6)))+(-0.01*((V(a4r5))*(V(a4r5))+(V(a4i5))*(V(a4i5))+(V(a8r5))*(V(a8r5))+(V(a8i5))*(V(a8i5))+(V(a12r5))*(V(a12r5))+(V(a12i5))*(V(a12i5)))*(V(a4r5)))))}
B4i5 a4i5 0 I={-(((-0.045*(V(a4i5)))+(0.16*(V(a4r4)-2*V(a4r5)+V(a4r6)))+(-0.01*((V(a4r5))*(V(a4r5))+(V(a4i5))*(V(a4i5))+(V(a8r5))*(V(a8r5))+(V(a8i5))*(V(a8i5))+(V(a12r5))*(V(a12r5))+(V(a12i5))*(V(a12i5)))*(V(a4i5)))))}
B8r5 a8r5 0 I={-(((-0.0486*(V(a8r5)))+(0*(V(a8i5)))+(-0.1472*(V(a8i4)-2*V(a8i5)+V(a8i6)))+(-0.01*((V(a4r5))*(V(a4r5))+(V(a4i5))*(V(a4i5))+(V(a8r5))*(V(a8r5))+(V(a8i5))*(V(a8i5))+(V(a12r5))*(V(a12r5))+(V(a12i5))*(V(a12i5)))*(V(a8r5)))+(0.13175*((((V(a4r5))*(V(a4r5))-(V(a4i5))*(V(a4i5))))*cos((3.87096774194+1.93*time))+((2*(V(a4r5))*(V(a4i5))))*sin((3.87096774194+1.93*time))))))}
B8i5 a8i5 0 I={-(((-0.0486*(V(a8i5)))+(-0*(V(a8r5)))+(0.1472*(V(a8r4)-2*V(a8r5)+V(a8r6)))+(-0.01*((V(a4r5))*(V(a4r5))+(V(a4i5))*(V(a4i5))+(V(a8r5))*(V(a8r5))+(V(a8i5))*(V(a8i5))+(V(a12r5))*(V(a12r5))+(V(a12i5))*(V(a12i5)))*(V(a8i5)))+(0.13175*(((2*(V(a4r5))*(V(a4i5))))*cos((3.87096774194+1.93*time))-(((V(a4r5))*(V(a4r5))-(V(a4i5))*(V(a4i5))))*sin((3.87096774194+1.93*time))))))}
B12r5 a12r5 0 I={-(((-0.0522*(V(a12r5)))+(0*(V(a12i5)))+(-0.1344*(V(a12i4)-2*V(a12i5)+V(a12i6)))+(-0.01*((V(a4r5))*(V(a4r5))+(V(a4i5))*(V(a4i5))+(V(a8r5))*(V(a8r5))+(V(a8i5))*(V(a8i5))+(V(a12r5))*(V(a12r5))+(V(a12i5))*(V(a12i5)))*(V(a12r5)))+(0.17825*((((V(a4r5))*(V(a8r5))-(V(a4i5))*(V(a8i5))))*cos((-3.87096774194+-3.71*time))+(((V(a4r5))*(V(a8i5))+(V(a4i5))*(V(a8r5))))*sin((-3.87096774194+-3.71*time))))))}
B12i5 a12i5 0 I={-(((-0.0522*(V(a12i5)))+(-0*(V(a12r5)))+(0.1344*(V(a12r4)-2*V(a12r5)+V(a12r6)))+(-0.01*((V(a4r5))*(V(a4r5))+(V(a4i5))*(V(a4i5))+(V(a8r5))*(V(a8r5))+(V(a8i5))*(V(a8i5))+(V(a12r5))*(V(a12r5))+(V(a12i5))*(V(a12i5)))*(V(a12i5)))+(0.17825*((((V(a4r5))*(V(a8i5))+(V(a4i5))*(V(a8r5))))*cos((-3.87096774194+-3.71*time))-(((V(a4r5))*(V(a8r5))-(V(a4i5))*(V(a8i5))))*sin((-3.87096774194+-3.71*time))))))}
Idrive4_5 a4r5 0 PWL(0 0 11.52 -0.0262044496205 78.72 -0.0262044496205 96 0)

Ca4r6 a4r6 0 1 ic=0
Ra4r6 a4r6 0 1e12
Ca4i6 a4i6 0 1 ic=0
Ra4i6 a4i6 0 1e12
Ca8r6 a8r6 0 1 ic=0
Ra8r6 a8r6 0 1e12
Ca8i6 a8i6 0 1 ic=0
Ra8i6 a8i6 0 1e12
Ca12r6 a12r6 0 1 ic=0
Ra12r6 a12r6 0 1e12
Ca12i6 a12i6 0 1 ic=0
Ra12i6 a12i6 0 1e12
B4r6 a4r6 0 I={-(((-0.045*(V(a4r6)))+(-0.16*(V(a4i5)-2*V(a4i6)+V(a4i7)))+(-0.01*((V(a4r6))*(V(a4r6))+(V(a4i6))*(V(a4i6))+(V(a8r6))*(V(a8r6))+(V(a8i6))*(V(a8i6))+(V(a12r6))*(V(a12r6))+(V(a12i6))*(V(a12i6)))*(V(a4r6)))))}
B4i6 a4i6 0 I={-(((-0.045*(V(a4i6)))+(0.16*(V(a4r5)-2*V(a4r6)+V(a4r7)))+(-0.01*((V(a4r6))*(V(a4r6))+(V(a4i6))*(V(a4i6))+(V(a8r6))*(V(a8r6))+(V(a8i6))*(V(a8i6))+(V(a12r6))*(V(a12r6))+(V(a12i6))*(V(a12i6)))*(V(a4i6)))))}
B8r6 a8r6 0 I={-(((-0.0486*(V(a8r6)))+(0*(V(a8i6)))+(-0.1472*(V(a8i5)-2*V(a8i6)+V(a8i7)))+(-0.01*((V(a4r6))*(V(a4r6))+(V(a4i6))*(V(a4i6))+(V(a8r6))*(V(a8r6))+(V(a8i6))*(V(a8i6))+(V(a12r6))*(V(a12r6))+(V(a12i6))*(V(a12i6)))*(V(a8r6)))+(0.13175*((((V(a4r6))*(V(a4r6))-(V(a4i6))*(V(a4i6))))*cos((4.64516129032+1.93*time))+((2*(V(a4r6))*(V(a4i6))))*sin((4.64516129032+1.93*time))))))}
B8i6 a8i6 0 I={-(((-0.0486*(V(a8i6)))+(-0*(V(a8r6)))+(0.1472*(V(a8r5)-2*V(a8r6)+V(a8r7)))+(-0.01*((V(a4r6))*(V(a4r6))+(V(a4i6))*(V(a4i6))+(V(a8r6))*(V(a8r6))+(V(a8i6))*(V(a8i6))+(V(a12r6))*(V(a12r6))+(V(a12i6))*(V(a12i6)))*(V(a8i6)))+(0.13175*(((2*(V(a4r6))*(V(a4i6))))*cos((4.64516129032+1.93*time))-(((V(a4r6))*(V(a4r6))-(V(a4i6))*(V(a4i6))))*sin((4.64516129032+1.93*time))))))}
B12r6 a12r6 0 I={-(((-0.0522*(V(a12r6)))+(0*(V(a12i6)))+(-0.1344*(V(a12i5)-2*V(a12i6)+V(a12i7)))+(-0.01*((V(a4r6))*(V(a4r6))+(V(a4i6))*(V(a4i6))+(V(a8r6))*(V(a8r6))+(V(a8i6))*(V(a8i6))+(V(a12r6))*(V(a12r6))+(V(a12i6))*(V(a12i6)))*(V(a12r6)))+(0.17825*((((V(a4r6))*(V(a8r6))-(V(a4i6))*(V(a8i6))))*cos((-4.64516129032+-3.71*time))+(((V(a4r6))*(V(a8i6))+(V(a4i6))*(V(a8r6))))*sin((-4.64516129032+-3.71*time))))))}
B12i6 a12i6 0 I={-(((-0.0522*(V(a12i6)))+(-0*(V(a12r6)))+(0.1344*(V(a12r5)-2*V(a12r6)+V(a12r7)))+(-0.01*((V(a4r6))*(V(a4r6))+(V(a4i6))*(V(a4i6))+(V(a8r6))*(V(a8r6))+(V(a8i6))*(V(a8i6))+(V(a12r6))*(V(a12r6))+(V(a12i6))*(V(a12i6)))*(V(a12i6)))+(0.17825*((((V(a4r6))*(V(a8i6))+(V(a4i6))*(V(a8r6))))*cos((-4.64516129032+-3.71*time))-(((V(a4r6))*(V(a8r6))-(V(a4i6))*(V(a8i6))))*sin((-4.64516129032+-3.71*time))))))}
Idrive4_6 a4r6 0 PWL(0 0 11.52 -0.0107153623856 78.72 -0.0107153623856 96 0)

Ca4r7 a4r7 0 1 ic=0
Ra4r7 a4r7 0 1e12
Ca4i7 a4i7 0 1 ic=0
Ra4i7 a4i7 0 1e12
Ca8r7 a8r7 0 1 ic=0
Ra8r7 a8r7 0 1e12
Ca8i7 a8i7 0 1 ic=0
Ra8i7 a8i7 0 1e12
Ca12r7 a12r7 0 1 ic=0
Ra12r7 a12r7 0 1e12
Ca12i7 a12i7 0 1 ic=0
Ra12i7 a12i7 0 1e12
B4r7 a4r7 0 I={-(((-0.045*(V(a4r7)))+(-0.16*(V(a4i6)-2*V(a4i7)+V(a4i8)))+(-0.01*((V(a4r7))*(V(a4r7))+(V(a4i7))*(V(a4i7))+(V(a8r7))*(V(a8r7))+(V(a8i7))*(V(a8i7))+(V(a12r7))*(V(a12r7))+(V(a12i7))*(V(a12i7)))*(V(a4r7)))))}
B4i7 a4i7 0 I={-(((-0.045*(V(a4i7)))+(0.16*(V(a4r6)-2*V(a4r7)+V(a4r8)))+(-0.01*((V(a4r7))*(V(a4r7))+(V(a4i7))*(V(a4i7))+(V(a8r7))*(V(a8r7))+(V(a8i7))*(V(a8i7))+(V(a12r7))*(V(a12r7))+(V(a12i7))*(V(a12i7)))*(V(a4i7)))))}
B8r7 a8r7 0 I={-(((-0.0486*(V(a8r7)))+(0*(V(a8i7)))+(-0.1472*(V(a8i6)-2*V(a8i7)+V(a8i8)))+(-0.01*((V(a4r7))*(V(a4r7))+(V(a4i7))*(V(a4i7))+(V(a8r7))*(V(a8r7))+(V(a8i7))*(V(a8i7))+(V(a12r7))*(V(a12r7))+(V(a12i7))*(V(a12i7)))*(V(a8r7)))+(0.13175*((((V(a4r7))*(V(a4r7))-(V(a4i7))*(V(a4i7))))*cos((5.41935483871+1.93*time))+((2*(V(a4r7))*(V(a4i7))))*sin((5.41935483871+1.93*time))))))}
B8i7 a8i7 0 I={-(((-0.0486*(V(a8i7)))+(-0*(V(a8r7)))+(0.1472*(V(a8r6)-2*V(a8r7)+V(a8r8)))+(-0.01*((V(a4r7))*(V(a4r7))+(V(a4i7))*(V(a4i7))+(V(a8r7))*(V(a8r7))+(V(a8i7))*(V(a8i7))+(V(a12r7))*(V(a12r7))+(V(a12i7))*(V(a12i7)))*(V(a8i7)))+(0.13175*(((2*(V(a4r7))*(V(a4i7))))*cos((5.41935483871+1.93*time))-(((V(a4r7))*(V(a4r7))-(V(a4i7))*(V(a4i7))))*sin((5.41935483871+1.93*time))))))}
B12r7 a12r7 0 I={-(((-0.0522*(V(a12r7)))+(0*(V(a12i7)))+(-0.1344*(V(a12i6)-2*V(a12i7)+V(a12i8)))+(-0.01*((V(a4r7))*(V(a4r7))+(V(a4i7))*(V(a4i7))+(V(a8r7))*(V(a8r7))+(V(a8i7))*(V(a8i7))+(V(a12r7))*(V(a12r7))+(V(a12i7))*(V(a12i7)))*(V(a12r7)))+(0.17825*((((V(a4r7))*(V(a8r7))-(V(a4i7))*(V(a8i7))))*cos((-5.41935483871+-3.71*time))+(((V(a4r7))*(V(a8i7))+(V(a4i7))*(V(a8r7))))*sin((-5.41935483871+-3.71*time))))))}
B12i7 a12i7 0 I={-(((-0.0522*(V(a12i7)))+(-0*(V(a12r7)))+(0.1344*(V(a12r6)-2*V(a12r7)+V(a12r8)))+(-0.01*((V(a4r7))*(V(a4r7))+(V(a4i7))*(V(a4i7))+(V(a8r7))*(V(a8r7))+(V(a8i7))*(V(a8i7))+(V(a12r7))*(V(a12r7))+(V(a12i7))*(V(a12i7)))*(V(a12i7)))+(0.17825*((((V(a4r7))*(V(a8i7))+(V(a4i7))*(V(a8r7))))*cos((-5.41935483871+-3.71*time))-(((V(a4r7))*(V(a8r7))-(V(a4i7))*(V(a8i7))))*sin((-5.41935483871+-3.71*time))))))}
Idrive4_7 a4r7 0 PWL(0 0 11.52 -0.0037241424752 78.72 -0.0037241424752 96 0)

Ca4r8 a4r8 0 1 ic=0
Ra4r8 a4r8 0 1e12
Ca4i8 a4i8 0 1 ic=0
Ra4i8 a4i8 0 1e12
Ca8r8 a8r8 0 1 ic=0
Ra8r8 a8r8 0 1e12
Ca8i8 a8i8 0 1 ic=0
Ra8i8 a8i8 0 1e12
Ca12r8 a12r8 0 1 ic=0
Ra12r8 a12r8 0 1e12
Ca12i8 a12i8 0 1 ic=0
Ra12i8 a12i8 0 1e12
B4r8 a4r8 0 I={-(((-0.045*(V(a4r8)))+(-0.16*(V(a4i7)-2*V(a4i8)+V(a4i9)))+(-0.01*((V(a4r8))*(V(a4r8))+(V(a4i8))*(V(a4i8))+(V(a8r8))*(V(a8r8))+(V(a8i8))*(V(a8i8))+(V(a12r8))*(V(a12r8))+(V(a12i8))*(V(a12i8)))*(V(a4r8)))))}
B4i8 a4i8 0 I={-(((-0.045*(V(a4i8)))+(0.16*(V(a4r7)-2*V(a4r8)+V(a4r9)))+(-0.01*((V(a4r8))*(V(a4r8))+(V(a4i8))*(V(a4i8))+(V(a8r8))*(V(a8r8))+(V(a8i8))*(V(a8i8))+(V(a12r8))*(V(a12r8))+(V(a12i8))*(V(a12i8)))*(V(a4i8)))))}
B8r8 a8r8 0 I={-(((-0.0486*(V(a8r8)))+(0*(V(a8i8)))+(-0.1472*(V(a8i7)-2*V(a8i8)+V(a8i9)))+(-0.01*((V(a4r8))*(V(a4r8))+(V(a4i8))*(V(a4i8))+(V(a8r8))*(V(a8r8))+(V(a8i8))*(V(a8i8))+(V(a12r8))*(V(a12r8))+(V(a12i8))*(V(a12i8)))*(V(a8r8)))+(0.13175*((((V(a4r8))*(V(a4r8))-(V(a4i8))*(V(a4i8))))*cos((6.1935483871+1.93*time))+((2*(V(a4r8))*(V(a4i8))))*sin((6.1935483871+1.93*time))))))}
B8i8 a8i8 0 I={-(((-0.0486*(V(a8i8)))+(-0*(V(a8r8)))+(0.1472*(V(a8r7)-2*V(a8r8)+V(a8r9)))+(-0.01*((V(a4r8))*(V(a4r8))+(V(a4i8))*(V(a4i8))+(V(a8r8))*(V(a8r8))+(V(a8i8))*(V(a8i8))+(V(a12r8))*(V(a12r8))+(V(a12i8))*(V(a12i8)))*(V(a8i8)))+(0.13175*(((2*(V(a4r8))*(V(a4i8))))*cos((6.1935483871+1.93*time))-(((V(a4r8))*(V(a4r8))-(V(a4i8))*(V(a4i8))))*sin((6.1935483871+1.93*time))))))}
B12r8 a12r8 0 I={-(((-0.0522*(V(a12r8)))+(0*(V(a12i8)))+(-0.1344*(V(a12i7)-2*V(a12i8)+V(a12i9)))+(-0.01*((V(a4r8))*(V(a4r8))+(V(a4i8))*(V(a4i8))+(V(a8r8))*(V(a8r8))+(V(a8i8))*(V(a8i8))+(V(a12r8))*(V(a12r8))+(V(a12i8))*(V(a12i8)))*(V(a12r8)))+(0.17825*((((V(a4r8))*(V(a8r8))-(V(a4i8))*(V(a8i8))))*cos((-6.1935483871+-3.71*time))+(((V(a4r8))*(V(a8i8))+(V(a4i8))*(V(a8r8))))*sin((-6.1935483871+-3.71*time))))))}
B12i8 a12i8 0 I={-(((-0.0522*(V(a12i8)))+(-0*(V(a12r8)))+(0.1344*(V(a12r7)-2*V(a12r8)+V(a12r9)))+(-0.01*((V(a4r8))*(V(a4r8))+(V(a4i8))*(V(a4i8))+(V(a8r8))*(V(a8r8))+(V(a8i8))*(V(a8i8))+(V(a12r8))*(V(a12r8))+(V(a12i8))*(V(a12i8)))*(V(a12i8)))+(0.17825*((((V(a4r8))*(V(a8i8))+(V(a4i8))*(V(a8r8))))*cos((-6.1935483871+-3.71*time))-(((V(a4r8))*(V(a8r8))-(V(a4i8))*(V(a8i8))))*sin((-6.1935483871+-3.71*time))))))}
Idrive4_8 a4r8 0 PWL(0 0 11.52 -0.00110010291544 78.72 -0.00110010291544 96 0)

Ca4r9 a4r9 0 1 ic=0
Ra4r9 a4r9 0 1e12
Ca4i9 a4i9 0 1 ic=0
Ra4i9 a4i9 0 1e12
Ca8r9 a8r9 0 1 ic=0
Ra8r9 a8r9 0 1e12
Ca8i9 a8i9 0 1 ic=0
Ra8i9 a8i9 0 1e12
Ca12r9 a12r9 0 1 ic=0
Ra12r9 a12r9 0 1e12
Ca12i9 a12i9 0 1 ic=0
Ra12i9 a12i9 0 1e12
B4r9 a4r9 0 I={-(((-0.045*(V(a4r9)))+(-0.16*(V(a4i8)-2*V(a4i9)+V(a4i10)))+(-0.01*((V(a4r9))*(V(a4r9))+(V(a4i9))*(V(a4i9))+(V(a8r9))*(V(a8r9))+(V(a8i9))*(V(a8i9))+(V(a12r9))*(V(a12r9))+(V(a12i9))*(V(a12i9)))*(V(a4r9)))))}
B4i9 a4i9 0 I={-(((-0.045*(V(a4i9)))+(0.16*(V(a4r8)-2*V(a4r9)+V(a4r10)))+(-0.01*((V(a4r9))*(V(a4r9))+(V(a4i9))*(V(a4i9))+(V(a8r9))*(V(a8r9))+(V(a8i9))*(V(a8i9))+(V(a12r9))*(V(a12r9))+(V(a12i9))*(V(a12i9)))*(V(a4i9)))))}
B8r9 a8r9 0 I={-(((-0.0486*(V(a8r9)))+(0*(V(a8i9)))+(-0.1472*(V(a8i8)-2*V(a8i9)+V(a8i10)))+(-0.01*((V(a4r9))*(V(a4r9))+(V(a4i9))*(V(a4i9))+(V(a8r9))*(V(a8r9))+(V(a8i9))*(V(a8i9))+(V(a12r9))*(V(a12r9))+(V(a12i9))*(V(a12i9)))*(V(a8r9)))+(0.13175*((((V(a4r9))*(V(a4r9))-(V(a4i9))*(V(a4i9))))*cos((6.96774193548+1.93*time))+((2*(V(a4r9))*(V(a4i9))))*sin((6.96774193548+1.93*time))))))}
B8i9 a8i9 0 I={-(((-0.0486*(V(a8i9)))+(-0*(V(a8r9)))+(0.1472*(V(a8r8)-2*V(a8r9)+V(a8r10)))+(-0.01*((V(a4r9))*(V(a4r9))+(V(a4i9))*(V(a4i9))+(V(a8r9))*(V(a8r9))+(V(a8i9))*(V(a8i9))+(V(a12r9))*(V(a12r9))+(V(a12i9))*(V(a12i9)))*(V(a8i9)))+(0.13175*(((2*(V(a4r9))*(V(a4i9))))*cos((6.96774193548+1.93*time))-(((V(a4r9))*(V(a4r9))-(V(a4i9))*(V(a4i9))))*sin((6.96774193548+1.93*time))))))}
B12r9 a12r9 0 I={-(((-0.0522*(V(a12r9)))+(0*(V(a12i9)))+(-0.1344*(V(a12i8)-2*V(a12i9)+V(a12i10)))+(-0.01*((V(a4r9))*(V(a4r9))+(V(a4i9))*(V(a4i9))+(V(a8r9))*(V(a8r9))+(V(a8i9))*(V(a8i9))+(V(a12r9))*(V(a12r9))+(V(a12i9))*(V(a12i9)))*(V(a12r9)))+(0.17825*((((V(a4r9))*(V(a8r9))-(V(a4i9))*(V(a8i9))))*cos((-6.96774193548+-3.71*time))+(((V(a4r9))*(V(a8i9))+(V(a4i9))*(V(a8r9))))*sin((-6.96774193548+-3.71*time))))))}
B12i9 a12i9 0 I={-(((-0.0522*(V(a12i9)))+(-0*(V(a12r9)))+(0.1344*(V(a12r8)-2*V(a12r9)+V(a12r10)))+(-0.01*((V(a4r9))*(V(a4r9))+(V(a4i9))*(V(a4i9))+(V(a8r9))*(V(a8r9))+(V(a8i9))*(V(a8i9))+(V(a12r9))*(V(a12r9))+(V(a12i9))*(V(a12i9)))*(V(a12i9)))+(0.17825*((((V(a4r9))*(V(a8i9))+(V(a4i9))*(V(a8r9))))*cos((-6.96774193548+-3.71*time))-(((V(a4r9))*(V(a8r9))-(V(a4i9))*(V(a8i9))))*sin((-6.96774193548+-3.71*time))))))}
Idrive4_9 a4r9 0 PWL(0 0 11.52 -0.000276202717688 78.72 -0.000276202717688 96 0)

Ca4r10 a4r10 0 1 ic=0
Ra4r10 a4r10 0 1e12
Ca4i10 a4i10 0 1 ic=0
Ra4i10 a4i10 0 1e12
Ca8r10 a8r10 0 1 ic=0
Ra8r10 a8r10 0 1e12
Ca8i10 a8i10 0 1 ic=0
Ra8i10 a8i10 0 1e12
Ca12r10 a12r10 0 1 ic=0
Ra12r10 a12r10 0 1e12
Ca12i10 a12i10 0 1 ic=0
Ra12i10 a12i10 0 1e12
B4r10 a4r10 0 I={-(((-0.045*(V(a4r10)))+(-0.16*(V(a4i9)-2*V(a4i10)+V(a4i11)))+(-0.01*((V(a4r10))*(V(a4r10))+(V(a4i10))*(V(a4i10))+(V(a8r10))*(V(a8r10))+(V(a8i10))*(V(a8i10))+(V(a12r10))*(V(a12r10))+(V(a12i10))*(V(a12i10)))*(V(a4r10)))))}
B4i10 a4i10 0 I={-(((-0.045*(V(a4i10)))+(0.16*(V(a4r9)-2*V(a4r10)+V(a4r11)))+(-0.01*((V(a4r10))*(V(a4r10))+(V(a4i10))*(V(a4i10))+(V(a8r10))*(V(a8r10))+(V(a8i10))*(V(a8i10))+(V(a12r10))*(V(a12r10))+(V(a12i10))*(V(a12i10)))*(V(a4i10)))))}
B8r10 a8r10 0 I={-(((-0.0486*(V(a8r10)))+(0*(V(a8i10)))+(-0.1472*(V(a8i9)-2*V(a8i10)+V(a8i11)))+(-0.01*((V(a4r10))*(V(a4r10))+(V(a4i10))*(V(a4i10))+(V(a8r10))*(V(a8r10))+(V(a8i10))*(V(a8i10))+(V(a12r10))*(V(a12r10))+(V(a12i10))*(V(a12i10)))*(V(a8r10)))+(0.13175*((((V(a4r10))*(V(a4r10))-(V(a4i10))*(V(a4i10))))*cos((7.74193548387+1.93*time))+((2*(V(a4r10))*(V(a4i10))))*sin((7.74193548387+1.93*time))))))}
B8i10 a8i10 0 I={-(((-0.0486*(V(a8i10)))+(-0*(V(a8r10)))+(0.1472*(V(a8r9)-2*V(a8r10)+V(a8r11)))+(-0.01*((V(a4r10))*(V(a4r10))+(V(a4i10))*(V(a4i10))+(V(a8r10))*(V(a8r10))+(V(a8i10))*(V(a8i10))+(V(a12r10))*(V(a12r10))+(V(a12i10))*(V(a12i10)))*(V(a8i10)))+(0.13175*(((2*(V(a4r10))*(V(a4i10))))*cos((7.74193548387+1.93*time))-(((V(a4r10))*(V(a4r10))-(V(a4i10))*(V(a4i10))))*sin((7.74193548387+1.93*time))))))}
B12r10 a12r10 0 I={-(((-0.0522*(V(a12r10)))+(0*(V(a12i10)))+(-0.1344*(V(a12i9)-2*V(a12i10)+V(a12i11)))+(-0.01*((V(a4r10))*(V(a4r10))+(V(a4i10))*(V(a4i10))+(V(a8r10))*(V(a8r10))+(V(a8i10))*(V(a8i10))+(V(a12r10))*(V(a12r10))+(V(a12i10))*(V(a12i10)))*(V(a12r10)))+(0.17825*((((V(a4r10))*(V(a8r10))-(V(a4i10))*(V(a8i10))))*cos((-7.74193548387+-3.71*time))+(((V(a4r10))*(V(a8i10))+(V(a4i10))*(V(a8r10))))*sin((-7.74193548387+-3.71*time))))))}
B12i10 a12i10 0 I={-(((-0.0522*(V(a12i10)))+(-0*(V(a12r10)))+(0.1344*(V(a12r9)-2*V(a12r10)+V(a12r11)))+(-0.01*((V(a4r10))*(V(a4r10))+(V(a4i10))*(V(a4i10))+(V(a8r10))*(V(a8r10))+(V(a8i10))*(V(a8i10))+(V(a12r10))*(V(a12r10))+(V(a12i10))*(V(a12i10)))*(V(a12i10)))+(0.17825*((((V(a4r10))*(V(a8i10))+(V(a4i10))*(V(a8r10))))*cos((-7.74193548387+-3.71*time))-(((V(a4r10))*(V(a8r10))-(V(a4i10))*(V(a8i10))))*sin((-7.74193548387+-3.71*time))))))}
Idrive4_10 a4r10 0 PWL(0 0 11.52 -5.89400070017e-05 78.72 -5.89400070017e-05 96 0)

Ca4r11 a4r11 0 1 ic=0
Ra4r11 a4r11 0 1e12
Ca4i11 a4i11 0 1 ic=0
Ra4i11 a4i11 0 1e12
Ca8r11 a8r11 0 1 ic=0
Ra8r11 a8r11 0 1e12
Ca8i11 a8i11 0 1 ic=0
Ra8i11 a8i11 0 1e12
Ca12r11 a12r11 0 1 ic=0
Ra12r11 a12r11 0 1e12
Ca12i11 a12i11 0 1 ic=0
Ra12i11 a12i11 0 1e12
B4r11 a4r11 0 I={-(((-0.045*(V(a4r11)))+(-0.16*(V(a4i10)-2*V(a4i11)+V(a4i12)))+(-0.01*((V(a4r11))*(V(a4r11))+(V(a4i11))*(V(a4i11))+(V(a8r11))*(V(a8r11))+(V(a8i11))*(V(a8i11))+(V(a12r11))*(V(a12r11))+(V(a12i11))*(V(a12i11)))*(V(a4r11)))))}
B4i11 a4i11 0 I={-(((-0.045*(V(a4i11)))+(0.16*(V(a4r10)-2*V(a4r11)+V(a4r12)))+(-0.01*((V(a4r11))*(V(a4r11))+(V(a4i11))*(V(a4i11))+(V(a8r11))*(V(a8r11))+(V(a8i11))*(V(a8i11))+(V(a12r11))*(V(a12r11))+(V(a12i11))*(V(a12i11)))*(V(a4i11)))))}
B8r11 a8r11 0 I={-(((-0.0486*(V(a8r11)))+(0*(V(a8i11)))+(-0.1472*(V(a8i10)-2*V(a8i11)+V(a8i12)))+(-0.01*((V(a4r11))*(V(a4r11))+(V(a4i11))*(V(a4i11))+(V(a8r11))*(V(a8r11))+(V(a8i11))*(V(a8i11))+(V(a12r11))*(V(a12r11))+(V(a12i11))*(V(a12i11)))*(V(a8r11)))+(0.13175*((((V(a4r11))*(V(a4r11))-(V(a4i11))*(V(a4i11))))*cos((8.51612903226+1.93*time))+((2*(V(a4r11))*(V(a4i11))))*sin((8.51612903226+1.93*time))))))}
B8i11 a8i11 0 I={-(((-0.0486*(V(a8i11)))+(-0*(V(a8r11)))+(0.1472*(V(a8r10)-2*V(a8r11)+V(a8r12)))+(-0.01*((V(a4r11))*(V(a4r11))+(V(a4i11))*(V(a4i11))+(V(a8r11))*(V(a8r11))+(V(a8i11))*(V(a8i11))+(V(a12r11))*(V(a12r11))+(V(a12i11))*(V(a12i11)))*(V(a8i11)))+(0.13175*(((2*(V(a4r11))*(V(a4i11))))*cos((8.51612903226+1.93*time))-(((V(a4r11))*(V(a4r11))-(V(a4i11))*(V(a4i11))))*sin((8.51612903226+1.93*time))))))}
B12r11 a12r11 0 I={-(((-0.0522*(V(a12r11)))+(0*(V(a12i11)))+(-0.1344*(V(a12i10)-2*V(a12i11)+V(a12i12)))+(-0.01*((V(a4r11))*(V(a4r11))+(V(a4i11))*(V(a4i11))+(V(a8r11))*(V(a8r11))+(V(a8i11))*(V(a8i11))+(V(a12r11))*(V(a12r11))+(V(a12i11))*(V(a12i11)))*(V(a12r11)))+(0.17825*((((V(a4r11))*(V(a8r11))-(V(a4i11))*(V(a8i11))))*cos((-8.51612903226+-3.71*time))+(((V(a4r11))*(V(a8i11))+(V(a4i11))*(V(a8r11))))*sin((-8.51612903226+-3.71*time))))))}
B12i11 a12i11 0 I={-(((-0.0522*(V(a12i11)))+(-0*(V(a12r11)))+(0.1344*(V(a12r10)-2*V(a12r11)+V(a12r12)))+(-0.01*((V(a4r11))*(V(a4r11))+(V(a4i11))*(V(a4i11))+(V(a8r11))*(V(a8r11))+(V(a8i11))*(V(a8i11))+(V(a12r11))*(V(a12r11))+(V(a12i11))*(V(a12i11)))*(V(a12i11)))+(0.17825*((((V(a4r11))*(V(a8i11))+(V(a4i11))*(V(a8r11))))*cos((-8.51612903226+-3.71*time))-(((V(a4r11))*(V(a8r11))-(V(a4i11))*(V(a8i11))))*sin((-8.51612903226+-3.71*time))))))}
Idrive4_11 a4r11 0 PWL(0 0 11.52 -1.06900570386e-05 78.72 -1.06900570386e-05 96 0)

Ca4r12 a4r12 0 1 ic=0
Ra4r12 a4r12 0 1e12
Ca4i12 a4i12 0 1 ic=0
Ra4i12 a4i12 0 1e12
Ca8r12 a8r12 0 1 ic=0
Ra8r12 a8r12 0 1e12
Ca8i12 a8i12 0 1 ic=0
Ra8i12 a8i12 0 1e12
Ca12r12 a12r12 0 1 ic=0
Ra12r12 a12r12 0 1e12
Ca12i12 a12i12 0 1 ic=0
Ra12i12 a12i12 0 1e12
B4r12 a4r12 0 I={-(((-0.045*(V(a4r12)))+(-0.16*(V(a4i11)-2*V(a4i12)+V(a4i13)))+(-0.01*((V(a4r12))*(V(a4r12))+(V(a4i12))*(V(a4i12))+(V(a8r12))*(V(a8r12))+(V(a8i12))*(V(a8i12))+(V(a12r12))*(V(a12r12))+(V(a12i12))*(V(a12i12)))*(V(a4r12)))))}
B4i12 a4i12 0 I={-(((-0.045*(V(a4i12)))+(0.16*(V(a4r11)-2*V(a4r12)+V(a4r13)))+(-0.01*((V(a4r12))*(V(a4r12))+(V(a4i12))*(V(a4i12))+(V(a8r12))*(V(a8r12))+(V(a8i12))*(V(a8i12))+(V(a12r12))*(V(a12r12))+(V(a12i12))*(V(a12i12)))*(V(a4i12)))))}
B8r12 a8r12 0 I={-(((-0.0486*(V(a8r12)))+(0*(V(a8i12)))+(-0.1472*(V(a8i11)-2*V(a8i12)+V(a8i13)))+(-0.01*((V(a4r12))*(V(a4r12))+(V(a4i12))*(V(a4i12))+(V(a8r12))*(V(a8r12))+(V(a8i12))*(V(a8i12))+(V(a12r12))*(V(a12r12))+(V(a12i12))*(V(a12i12)))*(V(a8r12)))+(0.13175*((((V(a4r12))*(V(a4r12))-(V(a4i12))*(V(a4i12))))*cos((9.29032258065+1.93*time))+((2*(V(a4r12))*(V(a4i12))))*sin((9.29032258065+1.93*time))))))}
B8i12 a8i12 0 I={-(((-0.0486*(V(a8i12)))+(-0*(V(a8r12)))+(0.1472*(V(a8r11)-2*V(a8r12)+V(a8r13)))+(-0.01*((V(a4r12))*(V(a4r12))+(V(a4i12))*(V(a4i12))+(V(a8r12))*(V(a8r12))+(V(a8i12))*(V(a8i12))+(V(a12r12))*(V(a12r12))+(V(a12i12))*(V(a12i12)))*(V(a8i12)))+(0.13175*(((2*(V(a4r12))*(V(a4i12))))*cos((9.29032258065+1.93*time))-(((V(a4r12))*(V(a4r12))-(V(a4i12))*(V(a4i12))))*sin((9.29032258065+1.93*time))))))}
B12r12 a12r12 0 I={-(((-0.0522*(V(a12r12)))+(0*(V(a12i12)))+(-0.1344*(V(a12i11)-2*V(a12i12)+V(a12i13)))+(-0.01*((V(a4r12))*(V(a4r12))+(V(a4i12))*(V(a4i12))+(V(a8r12))*(V(a8r12))+(V(a8i12))*(V(a8i12))+(V(a12r12))*(V(a12r12))+(V(a12i12))*(V(a12i12)))*(V(a12r12)))+(0.17825*((((V(a4r12))*(V(a8r12))-(V(a4i12))*(V(a8i12))))*cos((-9.29032258065+-3.71*time))+(((V(a4r12))*(V(a8i12))+(V(a4i12))*(V(a8r12))))*sin((-9.29032258065+-3.71*time))))))}
B12i12 a12i12 0 I={-(((-0.0522*(V(a12i12)))+(-0*(V(a12r12)))+(0.1344*(V(a12r11)-2*V(a12r12)+V(a12r13)))+(-0.01*((V(a4r12))*(V(a4r12))+(V(a4i12))*(V(a4i12))+(V(a8r12))*(V(a8r12))+(V(a8i12))*(V(a8i12))+(V(a12r12))*(V(a12r12))+(V(a12i12))*(V(a12i12)))*(V(a12i12)))+(0.17825*((((V(a4r12))*(V(a8i12))+(V(a4i12))*(V(a8r12))))*cos((-9.29032258065+-3.71*time))-(((V(a4r12))*(V(a8r12))-(V(a4i12))*(V(a8i12))))*sin((-9.29032258065+-3.71*time))))))}
Idrive4_12 a4r12 0 PWL(0 0 11.52 -1.64792508835e-06 78.72 -1.64792508835e-06 96 0)

Ca4r13 a4r13 0 1 ic=0
Ra4r13 a4r13 0 1e12
Ca4i13 a4i13 0 1 ic=0
Ra4i13 a4i13 0 1e12
Ca8r13 a8r13 0 1 ic=0
Ra8r13 a8r13 0 1e12
Ca8i13 a8i13 0 1 ic=0
Ra8i13 a8i13 0 1e12
Ca12r13 a12r13 0 1 ic=0
Ra12r13 a12r13 0 1e12
Ca12i13 a12i13 0 1 ic=0
Ra12i13 a12i13 0 1e12
B4r13 a4r13 0 I={-(((-0.045*(V(a4r13)))+(-0.16*(V(a4i12)-2*V(a4i13)+V(a4i14)))+(-0.01*((V(a4r13))*(V(a4r13))+(V(a4i13))*(V(a4i13))+(V(a8r13))*(V(a8r13))+(V(a8i13))*(V(a8i13))+(V(a12r13))*(V(a12r13))+(V(a12i13))*(V(a12i13)))*(V(a4r13)))))}
B4i13 a4i13 0 I={-(((-0.045*(V(a4i13)))+(0.16*(V(a4r12)-2*V(a4r13)+V(a4r14)))+(-0.01*((V(a4r13))*(V(a4r13))+(V(a4i13))*(V(a4i13))+(V(a8r13))*(V(a8r13))+(V(a8i13))*(V(a8i13))+(V(a12r13))*(V(a12r13))+(V(a12i13))*(V(a12i13)))*(V(a4i13)))))}
B8r13 a8r13 0 I={-(((-0.0486*(V(a8r13)))+(0*(V(a8i13)))+(-0.1472*(V(a8i12)-2*V(a8i13)+V(a8i14)))+(-0.01*((V(a4r13))*(V(a4r13))+(V(a4i13))*(V(a4i13))+(V(a8r13))*(V(a8r13))+(V(a8i13))*(V(a8i13))+(V(a12r13))*(V(a12r13))+(V(a12i13))*(V(a12i13)))*(V(a8r13)))+(0.13175*((((V(a4r13))*(V(a4r13))-(V(a4i13))*(V(a4i13))))*cos((10.064516129+1.93*time))+((2*(V(a4r13))*(V(a4i13))))*sin((10.064516129+1.93*time))))))}
B8i13 a8i13 0 I={-(((-0.0486*(V(a8i13)))+(-0*(V(a8r13)))+(0.1472*(V(a8r12)-2*V(a8r13)+V(a8r14)))+(-0.01*((V(a4r13))*(V(a4r13))+(V(a4i13))*(V(a4i13))+(V(a8r13))*(V(a8r13))+(V(a8i13))*(V(a8i13))+(V(a12r13))*(V(a12r13))+(V(a12i13))*(V(a12i13)))*(V(a8i13)))+(0.13175*(((2*(V(a4r13))*(V(a4i13))))*cos((10.064516129+1.93*time))-(((V(a4r13))*(V(a4r13))-(V(a4i13))*(V(a4i13))))*sin((10.064516129+1.93*time))))))}
B12r13 a12r13 0 I={-(((-0.0522*(V(a12r13)))+(0*(V(a12i13)))+(-0.1344*(V(a12i12)-2*V(a12i13)+V(a12i14)))+(-0.01*((V(a4r13))*(V(a4r13))+(V(a4i13))*(V(a4i13))+(V(a8r13))*(V(a8r13))+(V(a8i13))*(V(a8i13))+(V(a12r13))*(V(a12r13))+(V(a12i13))*(V(a12i13)))*(V(a12r13)))+(0.17825*((((V(a4r13))*(V(a8r13))-(V(a4i13))*(V(a8i13))))*cos((-10.064516129+-3.71*time))+(((V(a4r13))*(V(a8i13))+(V(a4i13))*(V(a8r13))))*sin((-10.064516129+-3.71*time))))))}
B12i13 a12i13 0 I={-(((-0.0522*(V(a12i13)))+(-0*(V(a12r13)))+(0.1344*(V(a12r12)-2*V(a12r13)+V(a12r14)))+(-0.01*((V(a4r13))*(V(a4r13))+(V(a4i13))*(V(a4i13))+(V(a8r13))*(V(a8r13))+(V(a8i13))*(V(a8i13))+(V(a12r13))*(V(a12r13))+(V(a12i13))*(V(a12i13)))*(V(a12i13)))+(0.17825*((((V(a4r13))*(V(a8i13))+(V(a4i13))*(V(a8r13))))*cos((-10.064516129+-3.71*time))-(((V(a4r13))*(V(a8r13))-(V(a4i13))*(V(a8i13))))*sin((-10.064516129+-3.71*time))))))}
Idrive4_13 a4r13 0 PWL(0 0 11.52 -2.1591484978e-07 78.72 -2.1591484978e-07 96 0)

Ca4r14 a4r14 0 1 ic=0
Ra4r14 a4r14 0 1e12
Ca4i14 a4i14 0 1 ic=0
Ra4i14 a4i14 0 1e12
Ca8r14 a8r14 0 1 ic=0
Ra8r14 a8r14 0 1e12
Ca8i14 a8i14 0 1 ic=0
Ra8i14 a8i14 0 1e12
Ca12r14 a12r14 0 1 ic=0
Ra12r14 a12r14 0 1e12
Ca12i14 a12i14 0 1 ic=0
Ra12i14 a12i14 0 1e12
B4r14 a4r14 0 I={-(((-0.045*(V(a4r14)))+(-0.16*(V(a4i13)-2*V(a4i14)+V(a4i15)))+(-0.01*((V(a4r14))*(V(a4r14))+(V(a4i14))*(V(a4i14))+(V(a8r14))*(V(a8r14))+(V(a8i14))*(V(a8i14))+(V(a12r14))*(V(a12r14))+(V(a12i14))*(V(a12i14)))*(V(a4r14)))))}
B4i14 a4i14 0 I={-(((-0.045*(V(a4i14)))+(0.16*(V(a4r13)-2*V(a4r14)+V(a4r15)))+(-0.01*((V(a4r14))*(V(a4r14))+(V(a4i14))*(V(a4i14))+(V(a8r14))*(V(a8r14))+(V(a8i14))*(V(a8i14))+(V(a12r14))*(V(a12r14))+(V(a12i14))*(V(a12i14)))*(V(a4i14)))))}
B8r14 a8r14 0 I={-(((-0.0486*(V(a8r14)))+(0*(V(a8i14)))+(-0.1472*(V(a8i13)-2*V(a8i14)+V(a8i15)))+(-0.01*((V(a4r14))*(V(a4r14))+(V(a4i14))*(V(a4i14))+(V(a8r14))*(V(a8r14))+(V(a8i14))*(V(a8i14))+(V(a12r14))*(V(a12r14))+(V(a12i14))*(V(a12i14)))*(V(a8r14)))+(0.13175*((((V(a4r14))*(V(a4r14))-(V(a4i14))*(V(a4i14))))*cos((10.8387096774+1.93*time))+((2*(V(a4r14))*(V(a4i14))))*sin((10.8387096774+1.93*time))))))}
B8i14 a8i14 0 I={-(((-0.0486*(V(a8i14)))+(-0*(V(a8r14)))+(0.1472*(V(a8r13)-2*V(a8r14)+V(a8r15)))+(-0.01*((V(a4r14))*(V(a4r14))+(V(a4i14))*(V(a4i14))+(V(a8r14))*(V(a8r14))+(V(a8i14))*(V(a8i14))+(V(a12r14))*(V(a12r14))+(V(a12i14))*(V(a12i14)))*(V(a8i14)))+(0.13175*(((2*(V(a4r14))*(V(a4i14))))*cos((10.8387096774+1.93*time))-(((V(a4r14))*(V(a4r14))-(V(a4i14))*(V(a4i14))))*sin((10.8387096774+1.93*time))))))}
B12r14 a12r14 0 I={-(((-0.0522*(V(a12r14)))+(0*(V(a12i14)))+(-0.1344*(V(a12i13)-2*V(a12i14)+V(a12i15)))+(-0.01*((V(a4r14))*(V(a4r14))+(V(a4i14))*(V(a4i14))+(V(a8r14))*(V(a8r14))+(V(a8i14))*(V(a8i14))+(V(a12r14))*(V(a12r14))+(V(a12i14))*(V(a12i14)))*(V(a12r14)))+(0.17825*((((V(a4r14))*(V(a8r14))-(V(a4i14))*(V(a8i14))))*cos((-10.8387096774+-3.71*time))+(((V(a4r14))*(V(a8i14))+(V(a4i14))*(V(a8r14))))*sin((-10.8387096774+-3.71*time))))))}
B12i14 a12i14 0 I={-(((-0.0522*(V(a12i14)))+(-0*(V(a12r14)))+(0.1344*(V(a12r13)-2*V(a12r14)+V(a12r15)))+(-0.01*((V(a4r14))*(V(a4r14))+(V(a4i14))*(V(a4i14))+(V(a8r14))*(V(a8r14))+(V(a8i14))*(V(a8i14))+(V(a12r14))*(V(a12r14))+(V(a12i14))*(V(a12i14)))*(V(a12i14)))+(0.17825*((((V(a4r14))*(V(a8i14))+(V(a4i14))*(V(a8r14))))*cos((-10.8387096774+-3.71*time))-(((V(a4r14))*(V(a8r14))-(V(a4i14))*(V(a8i14))))*sin((-10.8387096774+-3.71*time))))))}
Idrive4_14 a4r14 0 PWL(0 0 11.52 -2.4044467479e-08 78.72 -2.4044467479e-08 96 0)

Ca4r15 a4r15 0 1 ic=0
Ra4r15 a4r15 0 1e12
Ca4i15 a4i15 0 1 ic=0
Ra4i15 a4i15 0 1e12
Ca8r15 a8r15 0 1 ic=0
Ra8r15 a8r15 0 1e12
Ca8i15 a8i15 0 1 ic=0
Ra8i15 a8i15 0 1e12
Ca12r15 a12r15 0 1 ic=0
Ra12r15 a12r15 0 1e12
Ca12i15 a12i15 0 1 ic=0
Ra12i15 a12i15 0 1e12
B4r15 a4r15 0 I={-(((-0.045*(V(a4r15)))+(-0.16*(V(a4i14)-2*V(a4i15)+V(a4i16)))+(-0.01*((V(a4r15))*(V(a4r15))+(V(a4i15))*(V(a4i15))+(V(a8r15))*(V(a8r15))+(V(a8i15))*(V(a8i15))+(V(a12r15))*(V(a12r15))+(V(a12i15))*(V(a12i15)))*(V(a4r15)))))}
B4i15 a4i15 0 I={-(((-0.045*(V(a4i15)))+(0.16*(V(a4r14)-2*V(a4r15)+V(a4r16)))+(-0.01*((V(a4r15))*(V(a4r15))+(V(a4i15))*(V(a4i15))+(V(a8r15))*(V(a8r15))+(V(a8i15))*(V(a8i15))+(V(a12r15))*(V(a12r15))+(V(a12i15))*(V(a12i15)))*(V(a4i15)))))}
B8r15 a8r15 0 I={-(((-0.0486*(V(a8r15)))+(0*(V(a8i15)))+(-0.1472*(V(a8i14)-2*V(a8i15)+V(a8i16)))+(-0.01*((V(a4r15))*(V(a4r15))+(V(a4i15))*(V(a4i15))+(V(a8r15))*(V(a8r15))+(V(a8i15))*(V(a8i15))+(V(a12r15))*(V(a12r15))+(V(a12i15))*(V(a12i15)))*(V(a8r15)))+(0.13175*((((V(a4r15))*(V(a4r15))-(V(a4i15))*(V(a4i15))))*cos((11.6129032258+1.93*time))+((2*(V(a4r15))*(V(a4i15))))*sin((11.6129032258+1.93*time))))))}
B8i15 a8i15 0 I={-(((-0.0486*(V(a8i15)))+(-0*(V(a8r15)))+(0.1472*(V(a8r14)-2*V(a8r15)+V(a8r16)))+(-0.01*((V(a4r15))*(V(a4r15))+(V(a4i15))*(V(a4i15))+(V(a8r15))*(V(a8r15))+(V(a8i15))*(V(a8i15))+(V(a12r15))*(V(a12r15))+(V(a12i15))*(V(a12i15)))*(V(a8i15)))+(0.13175*(((2*(V(a4r15))*(V(a4i15))))*cos((11.6129032258+1.93*time))-(((V(a4r15))*(V(a4r15))-(V(a4i15))*(V(a4i15))))*sin((11.6129032258+1.93*time))))))}
B12r15 a12r15 0 I={-(((-0.0522*(V(a12r15)))+(0*(V(a12i15)))+(-0.1344*(V(a12i14)-2*V(a12i15)+V(a12i16)))+(-0.01*((V(a4r15))*(V(a4r15))+(V(a4i15))*(V(a4i15))+(V(a8r15))*(V(a8r15))+(V(a8i15))*(V(a8i15))+(V(a12r15))*(V(a12r15))+(V(a12i15))*(V(a12i15)))*(V(a12r15)))+(0.17825*((((V(a4r15))*(V(a8r15))-(V(a4i15))*(V(a8i15))))*cos((-11.6129032258+-3.71*time))+(((V(a4r15))*(V(a8i15))+(V(a4i15))*(V(a8r15))))*sin((-11.6129032258+-3.71*time))))))}
B12i15 a12i15 0 I={-(((-0.0522*(V(a12i15)))+(-0*(V(a12r15)))+(0.1344*(V(a12r14)-2*V(a12r15)+V(a12r16)))+(-0.01*((V(a4r15))*(V(a4r15))+(V(a4i15))*(V(a4i15))+(V(a8r15))*(V(a8r15))+(V(a8i15))*(V(a8i15))+(V(a12r15))*(V(a12r15))+(V(a12i15))*(V(a12i15)))*(V(a12i15)))+(0.17825*((((V(a4r15))*(V(a8i15))+(V(a4i15))*(V(a8r15))))*cos((-11.6129032258+-3.71*time))-(((V(a4r15))*(V(a8r15))-(V(a4i15))*(V(a8i15))))*sin((-11.6129032258+-3.71*time))))))}
Idrive4_15 a4r15 0 PWL(0 0 11.52 -2.27580693974e-09 78.72 -2.27580693974e-09 96 0)

Ca4r16 a4r16 0 1 ic=0
Ra4r16 a4r16 0 1e12
Ca4i16 a4i16 0 1 ic=0
Ra4i16 a4i16 0 1e12
Ca8r16 a8r16 0 1 ic=0
Ra8r16 a8r16 0 1e12
Ca8i16 a8i16 0 1 ic=0
Ra8i16 a8i16 0 1e12
Ca12r16 a12r16 0 1 ic=0
Ra12r16 a12r16 0 1e12
Ca12i16 a12i16 0 1 ic=0
Ra12i16 a12i16 0 1e12
B4r16 a4r16 0 I={-(((-0.045*(V(a4r16)))+(-0.16*(V(a4i15)-2*V(a4i16)+V(a4i17)))+(-0.01*((V(a4r16))*(V(a4r16))+(V(a4i16))*(V(a4i16))+(V(a8r16))*(V(a8r16))+(V(a8i16))*(V(a8i16))+(V(a12r16))*(V(a12r16))+(V(a12i16))*(V(a12i16)))*(V(a4r16)))))}
B4i16 a4i16 0 I={-(((-0.045*(V(a4i16)))+(0.16*(V(a4r15)-2*V(a4r16)+V(a4r17)))+(-0.01*((V(a4r16))*(V(a4r16))+(V(a4i16))*(V(a4i16))+(V(a8r16))*(V(a8r16))+(V(a8i16))*(V(a8i16))+(V(a12r16))*(V(a12r16))+(V(a12i16))*(V(a12i16)))*(V(a4i16)))))}
B8r16 a8r16 0 I={-(((-0.0486*(V(a8r16)))+(0*(V(a8i16)))+(-0.1472*(V(a8i15)-2*V(a8i16)+V(a8i17)))+(-0.01*((V(a4r16))*(V(a4r16))+(V(a4i16))*(V(a4i16))+(V(a8r16))*(V(a8r16))+(V(a8i16))*(V(a8i16))+(V(a12r16))*(V(a12r16))+(V(a12i16))*(V(a12i16)))*(V(a8r16)))+(0.13175*((((V(a4r16))*(V(a4r16))-(V(a4i16))*(V(a4i16))))*cos((12.3870967742+1.93*time))+((2*(V(a4r16))*(V(a4i16))))*sin((12.3870967742+1.93*time))))))}
B8i16 a8i16 0 I={-(((-0.0486*(V(a8i16)))+(-0*(V(a8r16)))+(0.1472*(V(a8r15)-2*V(a8r16)+V(a8r17)))+(-0.01*((V(a4r16))*(V(a4r16))+(V(a4i16))*(V(a4i16))+(V(a8r16))*(V(a8r16))+(V(a8i16))*(V(a8i16))+(V(a12r16))*(V(a12r16))+(V(a12i16))*(V(a12i16)))*(V(a8i16)))+(0.13175*(((2*(V(a4r16))*(V(a4i16))))*cos((12.3870967742+1.93*time))-(((V(a4r16))*(V(a4r16))-(V(a4i16))*(V(a4i16))))*sin((12.3870967742+1.93*time))))))}
B12r16 a12r16 0 I={-(((-0.0522*(V(a12r16)))+(0*(V(a12i16)))+(-0.1344*(V(a12i15)-2*V(a12i16)+V(a12i17)))+(-0.01*((V(a4r16))*(V(a4r16))+(V(a4i16))*(V(a4i16))+(V(a8r16))*(V(a8r16))+(V(a8i16))*(V(a8i16))+(V(a12r16))*(V(a12r16))+(V(a12i16))*(V(a12i16)))*(V(a12r16)))+(0.17825*((((V(a4r16))*(V(a8r16))-(V(a4i16))*(V(a8i16))))*cos((-12.3870967742+-3.71*time))+(((V(a4r16))*(V(a8i16))+(V(a4i16))*(V(a8r16))))*sin((-12.3870967742+-3.71*time))))))}
B12i16 a12i16 0 I={-(((-0.0522*(V(a12i16)))+(-0*(V(a12r16)))+(0.1344*(V(a12r15)-2*V(a12r16)+V(a12r17)))+(-0.01*((V(a4r16))*(V(a4r16))+(V(a4i16))*(V(a4i16))+(V(a8r16))*(V(a8r16))+(V(a8i16))*(V(a8i16))+(V(a12r16))*(V(a12r16))+(V(a12i16))*(V(a12i16)))*(V(a12i16)))+(0.17825*((((V(a4r16))*(V(a8i16))+(V(a4i16))*(V(a8r16))))*cos((-12.3870967742+-3.71*time))-(((V(a4r16))*(V(a8r16))-(V(a4i16))*(V(a8i16))))*sin((-12.3870967742+-3.71*time))))))}
Idrive4_16 a4r16 0 PWL(0 0 11.52 -1.83080999834e-10 78.72 -1.83080999834e-10 96 0)

Ca4r17 a4r17 0 1 ic=0
Ra4r17 a4r17 0 1e12
Ca4i17 a4i17 0 1 ic=0
Ra4i17 a4i17 0 1e12
Ca8r17 a8r17 0 1 ic=0
Ra8r17 a8r17 0 1e12
Ca8i17 a8i17 0 1 ic=0
Ra8i17 a8i17 0 1e12
Ca12r17 a12r17 0 1 ic=0
Ra12r17 a12r17 0 1e12
Ca12i17 a12i17 0 1 ic=0
Ra12i17 a12i17 0 1e12
B4r17 a4r17 0 I={-(((-0.045*(V(a4r17)))+(-0.16*(V(a4i16)-2*V(a4i17)+V(a4i18)))+(-0.01*((V(a4r17))*(V(a4r17))+(V(a4i17))*(V(a4i17))+(V(a8r17))*(V(a8r17))+(V(a8i17))*(V(a8i17))+(V(a12r17))*(V(a12r17))+(V(a12i17))*(V(a12i17)))*(V(a4r17)))))}
B4i17 a4i17 0 I={-(((-0.045*(V(a4i17)))+(0.16*(V(a4r16)-2*V(a4r17)+V(a4r18)))+(-0.01*((V(a4r17))*(V(a4r17))+(V(a4i17))*(V(a4i17))+(V(a8r17))*(V(a8r17))+(V(a8i17))*(V(a8i17))+(V(a12r17))*(V(a12r17))+(V(a12i17))*(V(a12i17)))*(V(a4i17)))))}
B8r17 a8r17 0 I={-(((-0.0486*(V(a8r17)))+(0*(V(a8i17)))+(-0.1472*(V(a8i16)-2*V(a8i17)+V(a8i18)))+(-0.01*((V(a4r17))*(V(a4r17))+(V(a4i17))*(V(a4i17))+(V(a8r17))*(V(a8r17))+(V(a8i17))*(V(a8i17))+(V(a12r17))*(V(a12r17))+(V(a12i17))*(V(a12i17)))*(V(a8r17)))+(0.13175*((((V(a4r17))*(V(a4r17))-(V(a4i17))*(V(a4i17))))*cos((13.1612903226+1.93*time))+((2*(V(a4r17))*(V(a4i17))))*sin((13.1612903226+1.93*time))))))}
B8i17 a8i17 0 I={-(((-0.0486*(V(a8i17)))+(-0*(V(a8r17)))+(0.1472*(V(a8r16)-2*V(a8r17)+V(a8r18)))+(-0.01*((V(a4r17))*(V(a4r17))+(V(a4i17))*(V(a4i17))+(V(a8r17))*(V(a8r17))+(V(a8i17))*(V(a8i17))+(V(a12r17))*(V(a12r17))+(V(a12i17))*(V(a12i17)))*(V(a8i17)))+(0.13175*(((2*(V(a4r17))*(V(a4i17))))*cos((13.1612903226+1.93*time))-(((V(a4r17))*(V(a4r17))-(V(a4i17))*(V(a4i17))))*sin((13.1612903226+1.93*time))))))}
B12r17 a12r17 0 I={-(((-0.0522*(V(a12r17)))+(0*(V(a12i17)))+(-0.1344*(V(a12i16)-2*V(a12i17)+V(a12i18)))+(-0.01*((V(a4r17))*(V(a4r17))+(V(a4i17))*(V(a4i17))+(V(a8r17))*(V(a8r17))+(V(a8i17))*(V(a8i17))+(V(a12r17))*(V(a12r17))+(V(a12i17))*(V(a12i17)))*(V(a12r17)))+(0.17825*((((V(a4r17))*(V(a8r17))-(V(a4i17))*(V(a8i17))))*cos((-13.1612903226+-3.71*time))+(((V(a4r17))*(V(a8i17))+(V(a4i17))*(V(a8r17))))*sin((-13.1612903226+-3.71*time))))))}
B12i17 a12i17 0 I={-(((-0.0522*(V(a12i17)))+(-0*(V(a12r17)))+(0.1344*(V(a12r16)-2*V(a12r17)+V(a12r18)))+(-0.01*((V(a4r17))*(V(a4r17))+(V(a4i17))*(V(a4i17))+(V(a8r17))*(V(a8r17))+(V(a8i17))*(V(a8i17))+(V(a12r17))*(V(a12r17))+(V(a12i17))*(V(a12i17)))*(V(a12i17)))+(0.17825*((((V(a4r17))*(V(a8i17))+(V(a4i17))*(V(a8r17))))*cos((-13.1612903226+-3.71*time))-(((V(a4r17))*(V(a8r17))-(V(a4i17))*(V(a8i17))))*sin((-13.1612903226+-3.71*time))))))}
Idrive4_17 a4r17 0 PWL(0 0 11.52 -1.25181092469e-11 78.72 -1.25181092469e-11 96 0)

Ca4r18 a4r18 0 1 ic=0
Ra4r18 a4r18 0 1e12
Ca4i18 a4i18 0 1 ic=0
Ra4i18 a4i18 0 1e12
Ca8r18 a8r18 0 1 ic=0
Ra8r18 a8r18 0 1e12
Ca8i18 a8i18 0 1 ic=0
Ra8i18 a8i18 0 1e12
Ca12r18 a12r18 0 1 ic=0
Ra12r18 a12r18 0 1e12
Ca12i18 a12i18 0 1 ic=0
Ra12i18 a12i18 0 1e12
B4r18 a4r18 0 I={-(((-0.045*(V(a4r18)))+(-0.16*(V(a4i17)-2*V(a4i18)+V(a4i19)))+(-0.01*((V(a4r18))*(V(a4r18))+(V(a4i18))*(V(a4i18))+(V(a8r18))*(V(a8r18))+(V(a8i18))*(V(a8i18))+(V(a12r18))*(V(a12r18))+(V(a12i18))*(V(a12i18)))*(V(a4r18)))))}
B4i18 a4i18 0 I={-(((-0.045*(V(a4i18)))+(0.16*(V(a4r17)-2*V(a4r18)+V(a4r19)))+(-0.01*((V(a4r18))*(V(a4r18))+(V(a4i18))*(V(a4i18))+(V(a8r18))*(V(a8r18))+(V(a8i18))*(V(a8i18))+(V(a12r18))*(V(a12r18))+(V(a12i18))*(V(a12i18)))*(V(a4i18)))))}
B8r18 a8r18 0 I={-(((-0.0486*(V(a8r18)))+(0*(V(a8i18)))+(-0.1472*(V(a8i17)-2*V(a8i18)+V(a8i19)))+(-0.01*((V(a4r18))*(V(a4r18))+(V(a4i18))*(V(a4i18))+(V(a8r18))*(V(a8r18))+(V(a8i18))*(V(a8i18))+(V(a12r18))*(V(a12r18))+(V(a12i18))*(V(a12i18)))*(V(a8r18)))+(0.13175*((((V(a4r18))*(V(a4r18))-(V(a4i18))*(V(a4i18))))*cos((13.935483871+1.93*time))+((2*(V(a4r18))*(V(a4i18))))*sin((13.935483871+1.93*time))))))}
B8i18 a8i18 0 I={-(((-0.0486*(V(a8i18)))+(-0*(V(a8r18)))+(0.1472*(V(a8r17)-2*V(a8r18)+V(a8r19)))+(-0.01*((V(a4r18))*(V(a4r18))+(V(a4i18))*(V(a4i18))+(V(a8r18))*(V(a8r18))+(V(a8i18))*(V(a8i18))+(V(a12r18))*(V(a12r18))+(V(a12i18))*(V(a12i18)))*(V(a8i18)))+(0.13175*(((2*(V(a4r18))*(V(a4i18))))*cos((13.935483871+1.93*time))-(((V(a4r18))*(V(a4r18))-(V(a4i18))*(V(a4i18))))*sin((13.935483871+1.93*time))))))}
B12r18 a12r18 0 I={-(((-0.0522*(V(a12r18)))+(0*(V(a12i18)))+(-0.1344*(V(a12i17)-2*V(a12i18)+V(a12i19)))+(-0.01*((V(a4r18))*(V(a4r18))+(V(a4i18))*(V(a4i18))+(V(a8r18))*(V(a8r18))+(V(a8i18))*(V(a8i18))+(V(a12r18))*(V(a12r18))+(V(a12i18))*(V(a12i18)))*(V(a12r18)))+(0.17825*((((V(a4r18))*(V(a8r18))-(V(a4i18))*(V(a8i18))))*cos((-13.935483871+-3.71*time))+(((V(a4r18))*(V(a8i18))+(V(a4i18))*(V(a8r18))))*sin((-13.935483871+-3.71*time))))))}
B12i18 a12i18 0 I={-(((-0.0522*(V(a12i18)))+(-0*(V(a12r18)))+(0.1344*(V(a12r17)-2*V(a12r18)+V(a12r19)))+(-0.01*((V(a4r18))*(V(a4r18))+(V(a4i18))*(V(a4i18))+(V(a8r18))*(V(a8r18))+(V(a8i18))*(V(a8i18))+(V(a12r18))*(V(a12r18))+(V(a12i18))*(V(a12i18)))*(V(a12i18)))+(0.17825*((((V(a4r18))*(V(a8i18))+(V(a4i18))*(V(a8r18))))*cos((-13.935483871+-3.71*time))-(((V(a4r18))*(V(a8r18))-(V(a4i18))*(V(a8i18))))*sin((-13.935483871+-3.71*time))))))}
Idrive4_18 a4r18 0 PWL(0 0 11.52 -7.27481247682e-13 78.72 -7.27481247682e-13 96 0)

Ca4r19 a4r19 0 1 ic=0
Ra4r19 a4r19 0 1e12
Ca4i19 a4i19 0 1 ic=0
Ra4i19 a4i19 0 1e12
Ca8r19 a8r19 0 1 ic=0
Ra8r19 a8r19 0 1e12
Ca8i19 a8i19 0 1 ic=0
Ra8i19 a8i19 0 1e12
Ca12r19 a12r19 0 1 ic=0
Ra12r19 a12r19 0 1e12
Ca12i19 a12i19 0 1 ic=0
Ra12i19 a12i19 0 1e12
B4r19 a4r19 0 I={-(((-0.045*(V(a4r19)))+(-0.16*(V(a4i18)-2*V(a4i19)+V(a4i20)))+(-0.01*((V(a4r19))*(V(a4r19))+(V(a4i19))*(V(a4i19))+(V(a8r19))*(V(a8r19))+(V(a8i19))*(V(a8i19))+(V(a12r19))*(V(a12r19))+(V(a12i19))*(V(a12i19)))*(V(a4r19)))))}
B4i19 a4i19 0 I={-(((-0.045*(V(a4i19)))+(0.16*(V(a4r18)-2*V(a4r19)+V(a4r20)))+(-0.01*((V(a4r19))*(V(a4r19))+(V(a4i19))*(V(a4i19))+(V(a8r19))*(V(a8r19))+(V(a8i19))*(V(a8i19))+(V(a12r19))*(V(a12r19))+(V(a12i19))*(V(a12i19)))*(V(a4i19)))))}
B8r19 a8r19 0 I={-(((-0.0486*(V(a8r19)))+(0*(V(a8i19)))+(-0.1472*(V(a8i18)-2*V(a8i19)+V(a8i20)))+(-0.01*((V(a4r19))*(V(a4r19))+(V(a4i19))*(V(a4i19))+(V(a8r19))*(V(a8r19))+(V(a8i19))*(V(a8i19))+(V(a12r19))*(V(a12r19))+(V(a12i19))*(V(a12i19)))*(V(a8r19)))+(0.13175*((((V(a4r19))*(V(a4r19))-(V(a4i19))*(V(a4i19))))*cos((14.7096774194+1.93*time))+((2*(V(a4r19))*(V(a4i19))))*sin((14.7096774194+1.93*time))))))}
B8i19 a8i19 0 I={-(((-0.0486*(V(a8i19)))+(-0*(V(a8r19)))+(0.1472*(V(a8r18)-2*V(a8r19)+V(a8r20)))+(-0.01*((V(a4r19))*(V(a4r19))+(V(a4i19))*(V(a4i19))+(V(a8r19))*(V(a8r19))+(V(a8i19))*(V(a8i19))+(V(a12r19))*(V(a12r19))+(V(a12i19))*(V(a12i19)))*(V(a8i19)))+(0.13175*(((2*(V(a4r19))*(V(a4i19))))*cos((14.7096774194+1.93*time))-(((V(a4r19))*(V(a4r19))-(V(a4i19))*(V(a4i19))))*sin((14.7096774194+1.93*time))))))}
B12r19 a12r19 0 I={-(((-0.0522*(V(a12r19)))+(0*(V(a12i19)))+(-0.1344*(V(a12i18)-2*V(a12i19)+V(a12i20)))+(-0.01*((V(a4r19))*(V(a4r19))+(V(a4i19))*(V(a4i19))+(V(a8r19))*(V(a8r19))+(V(a8i19))*(V(a8i19))+(V(a12r19))*(V(a12r19))+(V(a12i19))*(V(a12i19)))*(V(a12r19)))+(0.17825*((((V(a4r19))*(V(a8r19))-(V(a4i19))*(V(a8i19))))*cos((-14.7096774194+-3.71*time))+(((V(a4r19))*(V(a8i19))+(V(a4i19))*(V(a8r19))))*sin((-14.7096774194+-3.71*time))))))}
B12i19 a12i19 0 I={-(((-0.0522*(V(a12i19)))+(-0*(V(a12r19)))+(0.1344*(V(a12r18)-2*V(a12r19)+V(a12r20)))+(-0.01*((V(a4r19))*(V(a4r19))+(V(a4i19))*(V(a4i19))+(V(a8r19))*(V(a8r19))+(V(a8i19))*(V(a8i19))+(V(a12r19))*(V(a12r19))+(V(a12i19))*(V(a12i19)))*(V(a12i19)))+(0.17825*((((V(a4r19))*(V(a8i19))+(V(a4i19))*(V(a8r19))))*cos((-14.7096774194+-3.71*time))-(((V(a4r19))*(V(a8r19))-(V(a4i19))*(V(a8i19))))*sin((-14.7096774194+-3.71*time))))))}
Idrive4_19 a4r19 0 PWL(0 0 11.52 -3.5932916841e-14 78.72 -3.5932916841e-14 96 0)

Ca4r20 a4r20 0 1 ic=0
Ra4r20 a4r20 0 1e12
Ca4i20 a4i20 0 1 ic=0
Ra4i20 a4i20 0 1e12
Ca8r20 a8r20 0 1 ic=0
Ra8r20 a8r20 0 1e12
Ca8i20 a8i20 0 1 ic=0
Ra8i20 a8i20 0 1e12
Ca12r20 a12r20 0 1 ic=0
Ra12r20 a12r20 0 1e12
Ca12i20 a12i20 0 1 ic=0
Ra12i20 a12i20 0 1e12
B4r20 a4r20 0 I={-(((-0.045*(V(a4r20)))+(-0.16*(V(a4i19)-2*V(a4i20)+V(a4i21)))+(-0.01*((V(a4r20))*(V(a4r20))+(V(a4i20))*(V(a4i20))+(V(a8r20))*(V(a8r20))+(V(a8i20))*(V(a8i20))+(V(a12r20))*(V(a12r20))+(V(a12i20))*(V(a12i20)))*(V(a4r20)))))}
B4i20 a4i20 0 I={-(((-0.045*(V(a4i20)))+(0.16*(V(a4r19)-2*V(a4r20)+V(a4r21)))+(-0.01*((V(a4r20))*(V(a4r20))+(V(a4i20))*(V(a4i20))+(V(a8r20))*(V(a8r20))+(V(a8i20))*(V(a8i20))+(V(a12r20))*(V(a12r20))+(V(a12i20))*(V(a12i20)))*(V(a4i20)))))}
B8r20 a8r20 0 I={-(((-0.0486*(V(a8r20)))+(0*(V(a8i20)))+(-0.1472*(V(a8i19)-2*V(a8i20)+V(a8i21)))+(-0.01*((V(a4r20))*(V(a4r20))+(V(a4i20))*(V(a4i20))+(V(a8r20))*(V(a8r20))+(V(a8i20))*(V(a8i20))+(V(a12r20))*(V(a12r20))+(V(a12i20))*(V(a12i20)))*(V(a8r20)))+(0.13175*((((V(a4r20))*(V(a4r20))-(V(a4i20))*(V(a4i20))))*cos((15.4838709677+1.93*time))+((2*(V(a4r20))*(V(a4i20))))*sin((15.4838709677+1.93*time))))))}
B8i20 a8i20 0 I={-(((-0.0486*(V(a8i20)))+(-0*(V(a8r20)))+(0.1472*(V(a8r19)-2*V(a8r20)+V(a8r21)))+(-0.01*((V(a4r20))*(V(a4r20))+(V(a4i20))*(V(a4i20))+(V(a8r20))*(V(a8r20))+(V(a8i20))*(V(a8i20))+(V(a12r20))*(V(a12r20))+(V(a12i20))*(V(a12i20)))*(V(a8i20)))+(0.13175*(((2*(V(a4r20))*(V(a4i20))))*cos((15.4838709677+1.93*time))-(((V(a4r20))*(V(a4r20))-(V(a4i20))*(V(a4i20))))*sin((15.4838709677+1.93*time))))))}
B12r20 a12r20 0 I={-(((-0.0522*(V(a12r20)))+(0*(V(a12i20)))+(-0.1344*(V(a12i19)-2*V(a12i20)+V(a12i21)))+(-0.01*((V(a4r20))*(V(a4r20))+(V(a4i20))*(V(a4i20))+(V(a8r20))*(V(a8r20))+(V(a8i20))*(V(a8i20))+(V(a12r20))*(V(a12r20))+(V(a12i20))*(V(a12i20)))*(V(a12r20)))+(0.17825*((((V(a4r20))*(V(a8r20))-(V(a4i20))*(V(a8i20))))*cos((-15.4838709677+-3.71*time))+(((V(a4r20))*(V(a8i20))+(V(a4i20))*(V(a8r20))))*sin((-15.4838709677+-3.71*time))))))}
B12i20 a12i20 0 I={-(((-0.0522*(V(a12i20)))+(-0*(V(a12r20)))+(0.1344*(V(a12r19)-2*V(a12r20)+V(a12r21)))+(-0.01*((V(a4r20))*(V(a4r20))+(V(a4i20))*(V(a4i20))+(V(a8r20))*(V(a8r20))+(V(a8i20))*(V(a8i20))+(V(a12r20))*(V(a12r20))+(V(a12i20))*(V(a12i20)))*(V(a12i20)))+(0.17825*((((V(a4r20))*(V(a8i20))+(V(a4i20))*(V(a8r20))))*cos((-15.4838709677+-3.71*time))-(((V(a4r20))*(V(a8r20))-(V(a4i20))*(V(a8i20))))*sin((-15.4838709677+-3.71*time))))))}

Ca4r21 a4r21 0 1 ic=0
Ra4r21 a4r21 0 1e12
Ca4i21 a4i21 0 1 ic=0
Ra4i21 a4i21 0 1e12
Ca8r21 a8r21 0 1 ic=0
Ra8r21 a8r21 0 1e12
Ca8i21 a8i21 0 1 ic=0
Ra8i21 a8i21 0 1e12
Ca12r21 a12r21 0 1 ic=0
Ra12r21 a12r21 0 1e12
Ca12i21 a12i21 0 1 ic=0
Ra12i21 a12i21 0 1e12
B4r21 a4r21 0 I={-(((-0.045*(V(a4r21)))+(-0.16*(V(a4i20)-2*V(a4i21)+V(a4i22)))+(-0.01*((V(a4r21))*(V(a4r21))+(V(a4i21))*(V(a4i21))+(V(a8r21))*(V(a8r21))+(V(a8i21))*(V(a8i21))+(V(a12r21))*(V(a12r21))+(V(a12i21))*(V(a12i21)))*(V(a4r21)))))}
B4i21 a4i21 0 I={-(((-0.045*(V(a4i21)))+(0.16*(V(a4r20)-2*V(a4r21)+V(a4r22)))+(-0.01*((V(a4r21))*(V(a4r21))+(V(a4i21))*(V(a4i21))+(V(a8r21))*(V(a8r21))+(V(a8i21))*(V(a8i21))+(V(a12r21))*(V(a12r21))+(V(a12i21))*(V(a12i21)))*(V(a4i21)))))}
B8r21 a8r21 0 I={-(((-0.0486*(V(a8r21)))+(0*(V(a8i21)))+(-0.1472*(V(a8i20)-2*V(a8i21)+V(a8i22)))+(-0.01*((V(a4r21))*(V(a4r21))+(V(a4i21))*(V(a4i21))+(V(a8r21))*(V(a8r21))+(V(a8i21))*(V(a8i21))+(V(a12r21))*(V(a12r21))+(V(a12i21))*(V(a12i21)))*(V(a8r21)))+(0.13175*((((V(a4r21))*(V(a4r21))-(V(a4i21))*(V(a4i21))))*cos((16.2580645161+1.93*time))+((2*(V(a4r21))*(V(a4i21))))*sin((16.2580645161+1.93*time))))))}
B8i21 a8i21 0 I={-(((-0.0486*(V(a8i21)))+(-0*(V(a8r21)))+(0.1472*(V(a8r20)-2*V(a8r21)+V(a8r22)))+(-0.01*((V(a4r21))*(V(a4r21))+(V(a4i21))*(V(a4i21))+(V(a8r21))*(V(a8r21))+(V(a8i21))*(V(a8i21))+(V(a12r21))*(V(a12r21))+(V(a12i21))*(V(a12i21)))*(V(a8i21)))+(0.13175*(((2*(V(a4r21))*(V(a4i21))))*cos((16.2580645161+1.93*time))-(((V(a4r21))*(V(a4r21))-(V(a4i21))*(V(a4i21))))*sin((16.2580645161+1.93*time))))))}
B12r21 a12r21 0 I={-(((-0.0522*(V(a12r21)))+(0*(V(a12i21)))+(-0.1344*(V(a12i20)-2*V(a12i21)+V(a12i22)))+(-0.01*((V(a4r21))*(V(a4r21))+(V(a4i21))*(V(a4i21))+(V(a8r21))*(V(a8r21))+(V(a8i21))*(V(a8i21))+(V(a12r21))*(V(a12r21))+(V(a12i21))*(V(a12i21)))*(V(a12r21)))+(0.17825*((((V(a4r21))*(V(a8r21))-(V(a4i21))*(V(a8i21))))*cos((-16.2580645161+-3.71*time))+(((V(a4r21))*(V(a8i21))+(V(a4i21))*(V(a8r21))))*sin((-16.2580645161+-3.71*time))))))}
B12i21 a12i21 0 I={-(((-0.0522*(V(a12i21)))+(-0*(V(a12r21)))+(0.1344*(V(a12r20)-2*V(a12r21)+V(a12r22)))+(-0.01*((V(a4r21))*(V(a4r21))+(V(a4i21))*(V(a4i21))+(V(a8r21))*(V(a8r21))+(V(a8i21))*(V(a8i21))+(V(a12r21))*(V(a12r21))+(V(a12i21))*(V(a12i21)))*(V(a12i21)))+(0.17825*((((V(a4r21))*(V(a8i21))+(V(a4i21))*(V(a8r21))))*cos((-16.2580645161+-3.71*time))-(((V(a4r21))*(V(a8r21))-(V(a4i21))*(V(a8i21))))*sin((-16.2580645161+-3.71*time))))))}

Ca4r22 a4r22 0 1 ic=0
Ra4r22 a4r22 0 1e12
Ca4i22 a4i22 0 1 ic=0
Ra4i22 a4i22 0 1e12
Ca8r22 a8r22 0 1 ic=0
Ra8r22 a8r22 0 1e12
Ca8i22 a8i22 0 1 ic=0
Ra8i22 a8i22 0 1e12
Ca12r22 a12r22 0 1 ic=0
Ra12r22 a12r22 0 1e12
Ca12i22 a12i22 0 1 ic=0
Ra12i22 a12i22 0 1e12
B4r22 a4r22 0 I={-(((-0.045*(V(a4r22)))+(-0.16*(V(a4i21)-2*V(a4i22)+V(a4i23)))+(-0.01*((V(a4r22))*(V(a4r22))+(V(a4i22))*(V(a4i22))+(V(a8r22))*(V(a8r22))+(V(a8i22))*(V(a8i22))+(V(a12r22))*(V(a12r22))+(V(a12i22))*(V(a12i22)))*(V(a4r22)))))}
B4i22 a4i22 0 I={-(((-0.045*(V(a4i22)))+(0.16*(V(a4r21)-2*V(a4r22)+V(a4r23)))+(-0.01*((V(a4r22))*(V(a4r22))+(V(a4i22))*(V(a4i22))+(V(a8r22))*(V(a8r22))+(V(a8i22))*(V(a8i22))+(V(a12r22))*(V(a12r22))+(V(a12i22))*(V(a12i22)))*(V(a4i22)))))}
B8r22 a8r22 0 I={-(((-0.0486*(V(a8r22)))+(0*(V(a8i22)))+(-0.1472*(V(a8i21)-2*V(a8i22)+V(a8i23)))+(-0.01*((V(a4r22))*(V(a4r22))+(V(a4i22))*(V(a4i22))+(V(a8r22))*(V(a8r22))+(V(a8i22))*(V(a8i22))+(V(a12r22))*(V(a12r22))+(V(a12i22))*(V(a12i22)))*(V(a8r22)))+(0.13175*((((V(a4r22))*(V(a4r22))-(V(a4i22))*(V(a4i22))))*cos((17.0322580645+1.93*time))+((2*(V(a4r22))*(V(a4i22))))*sin((17.0322580645+1.93*time))))))}
B8i22 a8i22 0 I={-(((-0.0486*(V(a8i22)))+(-0*(V(a8r22)))+(0.1472*(V(a8r21)-2*V(a8r22)+V(a8r23)))+(-0.01*((V(a4r22))*(V(a4r22))+(V(a4i22))*(V(a4i22))+(V(a8r22))*(V(a8r22))+(V(a8i22))*(V(a8i22))+(V(a12r22))*(V(a12r22))+(V(a12i22))*(V(a12i22)))*(V(a8i22)))+(0.13175*(((2*(V(a4r22))*(V(a4i22))))*cos((17.0322580645+1.93*time))-(((V(a4r22))*(V(a4r22))-(V(a4i22))*(V(a4i22))))*sin((17.0322580645+1.93*time))))))}
B12r22 a12r22 0 I={-(((-0.0522*(V(a12r22)))+(0*(V(a12i22)))+(-0.1344*(V(a12i21)-2*V(a12i22)+V(a12i23)))+(-0.01*((V(a4r22))*(V(a4r22))+(V(a4i22))*(V(a4i22))+(V(a8r22))*(V(a8r22))+(V(a8i22))*(V(a8i22))+(V(a12r22))*(V(a12r22))+(V(a12i22))*(V(a12i22)))*(V(a12r22)))+(0.17825*((((V(a4r22))*(V(a8r22))-(V(a4i22))*(V(a8i22))))*cos((-17.0322580645+-3.71*time))+(((V(a4r22))*(V(a8i22))+(V(a4i22))*(V(a8r22))))*sin((-17.0322580645+-3.71*time))))))}
B12i22 a12i22 0 I={-(((-0.0522*(V(a12i22)))+(-0*(V(a12r22)))+(0.1344*(V(a12r21)-2*V(a12r22)+V(a12r23)))+(-0.01*((V(a4r22))*(V(a4r22))+(V(a4i22))*(V(a4i22))+(V(a8r22))*(V(a8r22))+(V(a8i22))*(V(a8i22))+(V(a12r22))*(V(a12r22))+(V(a12i22))*(V(a12i22)))*(V(a12i22)))+(0.17825*((((V(a4r22))*(V(a8i22))+(V(a4i22))*(V(a8r22))))*cos((-17.0322580645+-3.71*time))-(((V(a4r22))*(V(a8r22))-(V(a4i22))*(V(a8i22))))*sin((-17.0322580645+-3.71*time))))))}

Ca4r23 a4r23 0 1 ic=0
Ra4r23 a4r23 0 1e12
Ca4i23 a4i23 0 1 ic=0
Ra4i23 a4i23 0 1e12
Ca8r23 a8r23 0 1 ic=0
Ra8r23 a8r23 0 1e12
Ca8i23 a8i23 0 1 ic=0
Ra8i23 a8i23 0 1e12
Ca12r23 a12r23 0 1 ic=0
Ra12r23 a12r23 0 1e12
Ca12i23 a12i23 0 1 ic=0
Ra12i23 a12i23 0 1e12
B4r23 a4r23 0 I={-(((-0.045*(V(a4r23)))+(-0.16*(V(a4i22)-2*V(a4i23)+V(a4i24)))+(-0.01*((V(a4r23))*(V(a4r23))+(V(a4i23))*(V(a4i23))+(V(a8r23))*(V(a8r23))+(V(a8i23))*(V(a8i23))+(V(a12r23))*(V(a12r23))+(V(a12i23))*(V(a12i23)))*(V(a4r23)))))}
B4i23 a4i23 0 I={-(((-0.045*(V(a4i23)))+(0.16*(V(a4r22)-2*V(a4r23)+V(a4r24)))+(-0.01*((V(a4r23))*(V(a4r23))+(V(a4i23))*(V(a4i23))+(V(a8r23))*(V(a8r23))+(V(a8i23))*(V(a8i23))+(V(a12r23))*(V(a12r23))+(V(a12i23))*(V(a12i23)))*(V(a4i23)))))}
B8r23 a8r23 0 I={-(((-0.0486*(V(a8r23)))+(0*(V(a8i23)))+(-0.1472*(V(a8i22)-2*V(a8i23)+V(a8i24)))+(-0.01*((V(a4r23))*(V(a4r23))+(V(a4i23))*(V(a4i23))+(V(a8r23))*(V(a8r23))+(V(a8i23))*(V(a8i23))+(V(a12r23))*(V(a12r23))+(V(a12i23))*(V(a12i23)))*(V(a8r23)))+(0.13175*((((V(a4r23))*(V(a4r23))-(V(a4i23))*(V(a4i23))))*cos((17.8064516129+1.93*time))+((2*(V(a4r23))*(V(a4i23))))*sin((17.8064516129+1.93*time))))))}
B8i23 a8i23 0 I={-(((-0.0486*(V(a8i23)))+(-0*(V(a8r23)))+(0.1472*(V(a8r22)-2*V(a8r23)+V(a8r24)))+(-0.01*((V(a4r23))*(V(a4r23))+(V(a4i23))*(V(a4i23))+(V(a8r23))*(V(a8r23))+(V(a8i23))*(V(a8i23))+(V(a12r23))*(V(a12r23))+(V(a12i23))*(V(a12i23)))*(V(a8i23)))+(0.13175*(((2*(V(a4r23))*(V(a4i23))))*cos((17.8064516129+1.93*time))-(((V(a4r23))*(V(a4r23))-(V(a4i23))*(V(a4i23))))*sin((17.8064516129+1.93*time))))))}
B12r23 a12r23 0 I={-(((-0.0522*(V(a12r23)))+(0*(V(a12i23)))+(-0.1344*(V(a12i22)-2*V(a12i23)+V(a12i24)))+(-0.01*((V(a4r23))*(V(a4r23))+(V(a4i23))*(V(a4i23))+(V(a8r23))*(V(a8r23))+(V(a8i23))*(V(a8i23))+(V(a12r23))*(V(a12r23))+(V(a12i23))*(V(a12i23)))*(V(a12r23)))+(0.17825*((((V(a4r23))*(V(a8r23))-(V(a4i23))*(V(a8i23))))*cos((-17.8064516129+-3.71*time))+(((V(a4r23))*(V(a8i23))+(V(a4i23))*(V(a8r23))))*sin((-17.8064516129+-3.71*time))))))}
B12i23 a12i23 0 I={-(((-0.0522*(V(a12i23)))+(-0*(V(a12r23)))+(0.1344*(V(a12r22)-2*V(a12r23)+V(a12r24)))+(-0.01*((V(a4r23))*(V(a4r23))+(V(a4i23))*(V(a4i23))+(V(a8r23))*(V(a8r23))+(V(a8i23))*(V(a8i23))+(V(a12r23))*(V(a12r23))+(V(a12i23))*(V(a12i23)))*(V(a12i23)))+(0.17825*((((V(a4r23))*(V(a8i23))+(V(a4i23))*(V(a8r23))))*cos((-17.8064516129+-3.71*time))-(((V(a4r23))*(V(a8r23))-(V(a4i23))*(V(a8i23))))*sin((-17.8064516129+-3.71*time))))))}

Ca4r24 a4r24 0 1 ic=0
Ra4r24 a4r24 0 1e12
Ca4i24 a4i24 0 1 ic=0
Ra4i24 a4i24 0 1e12
Ca8r24 a8r24 0 1 ic=0
Ra8r24 a8r24 0 1e12
Ca8i24 a8i24 0 1 ic=0
Ra8i24 a8i24 0 1e12
Ca12r24 a12r24 0 1 ic=0
Ra12r24 a12r24 0 1e12
Ca12i24 a12i24 0 1 ic=0
Ra12i24 a12i24 0 1e12
B4r24 a4r24 0 I={-(((-0.045*(V(a4r24)))+(-0.16*(V(a4i23)-2*V(a4i24)+V(a4i25)))+(-0.01*((V(a4r24))*(V(a4r24))+(V(a4i24))*(V(a4i24))+(V(a8r24))*(V(a8r24))+(V(a8i24))*(V(a8i24))+(V(a12r24))*(V(a12r24))+(V(a12i24))*(V(a12i24)))*(V(a4r24)))))}
B4i24 a4i24 0 I={-(((-0.045*(V(a4i24)))+(0.16*(V(a4r23)-2*V(a4r24)+V(a4r25)))+(-0.01*((V(a4r24))*(V(a4r24))+(V(a4i24))*(V(a4i24))+(V(a8r24))*(V(a8r24))+(V(a8i24))*(V(a8i24))+(V(a12r24))*(V(a12r24))+(V(a12i24))*(V(a12i24)))*(V(a4i24)))))}
B8r24 a8r24 0 I={-(((-0.0486*(V(a8r24)))+(0*(V(a8i24)))+(-0.1472*(V(a8i23)-2*V(a8i24)+V(a8i25)))+(-0.01*((V(a4r24))*(V(a4r24))+(V(a4i24))*(V(a4i24))+(V(a8r24))*(V(a8r24))+(V(a8i24))*(V(a8i24))+(V(a12r24))*(V(a12r24))+(V(a12i24))*(V(a12i24)))*(V(a8r24)))+(0.13175*((((V(a4r24))*(V(a4r24))-(V(a4i24))*(V(a4i24))))*cos((18.5806451613+1.93*time))+((2*(V(a4r24))*(V(a4i24))))*sin((18.5806451613+1.93*time))))))}
B8i24 a8i24 0 I={-(((-0.0486*(V(a8i24)))+(-0*(V(a8r24)))+(0.1472*(V(a8r23)-2*V(a8r24)+V(a8r25)))+(-0.01*((V(a4r24))*(V(a4r24))+(V(a4i24))*(V(a4i24))+(V(a8r24))*(V(a8r24))+(V(a8i24))*(V(a8i24))+(V(a12r24))*(V(a12r24))+(V(a12i24))*(V(a12i24)))*(V(a8i24)))+(0.13175*(((2*(V(a4r24))*(V(a4i24))))*cos((18.5806451613+1.93*time))-(((V(a4r24))*(V(a4r24))-(V(a4i24))*(V(a4i24))))*sin((18.5806451613+1.93*time))))))}
B12r24 a12r24 0 I={-(((-0.0522*(V(a12r24)))+(0*(V(a12i24)))+(-0.1344*(V(a12i23)-2*V(a12i24)+V(a12i25)))+(-0.01*((V(a4r24))*(V(a4r24))+(V(a4i24))*(V(a4i24))+(V(a8r24))*(V(a8r24))+(V(a8i24))*(V(a8i24))+(V(a12r24))*(V(a12r24))+(V(a12i24))*(V(a12i24)))*(V(a12r24)))+(0.17825*((((V(a4r24))*(V(a8r24))-(V(a4i24))*(V(a8i24))))*cos((-18.5806451613+-3.71*time))+(((V(a4r24))*(V(a8i24))+(V(a4i24))*(V(a8r24))))*sin((-18.5806451613+-3.71*time))))))}
B12i24 a12i24 0 I={-(((-0.0522*(V(a12i24)))+(-0*(V(a12r24)))+(0.1344*(V(a12r23)-2*V(a12r24)+V(a12r25)))+(-0.01*((V(a4r24))*(V(a4r24))+(V(a4i24))*(V(a4i24))+(V(a8r24))*(V(a8r24))+(V(a8i24))*(V(a8i24))+(V(a12r24))*(V(a12r24))+(V(a12i24))*(V(a12i24)))*(V(a12i24)))+(0.17825*((((V(a4r24))*(V(a8i24))+(V(a4i24))*(V(a8r24))))*cos((-18.5806451613+-3.71*time))-(((V(a4r24))*(V(a8r24))-(V(a4i24))*(V(a8i24))))*sin((-18.5806451613+-3.71*time))))))}

Ca4r25 a4r25 0 1 ic=0
Ra4r25 a4r25 0 1e12
Ca4i25 a4i25 0 1 ic=0
Ra4i25 a4i25 0 1e12
Ca8r25 a8r25 0 1 ic=0
Ra8r25 a8r25 0 1e12
Ca8i25 a8i25 0 1 ic=0
Ra8i25 a8i25 0 1e12
Ca12r25 a12r25 0 1 ic=0
Ra12r25 a12r25 0 1e12
Ca12i25 a12i25 0 1 ic=0
Ra12i25 a12i25 0 1e12
B4r25 a4r25 0 I={-(((-0.045*(V(a4r25)))+(-0.16*(V(a4i24)-2*V(a4i25)+V(a4i26)))+(-0.01*((V(a4r25))*(V(a4r25))+(V(a4i25))*(V(a4i25))+(V(a8r25))*(V(a8r25))+(V(a8i25))*(V(a8i25))+(V(a12r25))*(V(a12r25))+(V(a12i25))*(V(a12i25)))*(V(a4r25)))))}
B4i25 a4i25 0 I={-(((-0.045*(V(a4i25)))+(0.16*(V(a4r24)-2*V(a4r25)+V(a4r26)))+(-0.01*((V(a4r25))*(V(a4r25))+(V(a4i25))*(V(a4i25))+(V(a8r25))*(V(a8r25))+(V(a8i25))*(V(a8i25))+(V(a12r25))*(V(a12r25))+(V(a12i25))*(V(a12i25)))*(V(a4i25)))))}
B8r25 a8r25 0 I={-(((-0.0486*(V(a8r25)))+(0*(V(a8i25)))+(-0.1472*(V(a8i24)-2*V(a8i25)+V(a8i26)))+(-0.01*((V(a4r25))*(V(a4r25))+(V(a4i25))*(V(a4i25))+(V(a8r25))*(V(a8r25))+(V(a8i25))*(V(a8i25))+(V(a12r25))*(V(a12r25))+(V(a12i25))*(V(a12i25)))*(V(a8r25)))+(0.13175*((((V(a4r25))*(V(a4r25))-(V(a4i25))*(V(a4i25))))*cos((19.3548387097+1.93*time))+((2*(V(a4r25))*(V(a4i25))))*sin((19.3548387097+1.93*time))))))}
B8i25 a8i25 0 I={-(((-0.0486*(V(a8i25)))+(-0*(V(a8r25)))+(0.1472*(V(a8r24)-2*V(a8r25)+V(a8r26)))+(-0.01*((V(a4r25))*(V(a4r25))+(V(a4i25))*(V(a4i25))+(V(a8r25))*(V(a8r25))+(V(a8i25))*(V(a8i25))+(V(a12r25))*(V(a12r25))+(V(a12i25))*(V(a12i25)))*(V(a8i25)))+(0.13175*(((2*(V(a4r25))*(V(a4i25))))*cos((19.3548387097+1.93*time))-(((V(a4r25))*(V(a4r25))-(V(a4i25))*(V(a4i25))))*sin((19.3548387097+1.93*time))))))}
B12r25 a12r25 0 I={-(((-0.0522*(V(a12r25)))+(0*(V(a12i25)))+(-0.1344*(V(a12i24)-2*V(a12i25)+V(a12i26)))+(-0.01*((V(a4r25))*(V(a4r25))+(V(a4i25))*(V(a4i25))+(V(a8r25))*(V(a8r25))+(V(a8i25))*(V(a8i25))+(V(a12r25))*(V(a12r25))+(V(a12i25))*(V(a12i25)))*(V(a12r25)))+(0.17825*((((V(a4r25))*(V(a8r25))-(V(a4i25))*(V(a8i25))))*cos((-19.3548387097+-3.71*time))+(((V(a4r25))*(V(a8i25))+(V(a4i25))*(V(a8r25))))*sin((-19.3548387097+-3.71*time))))))}
B12i25 a12i25 0 I={-(((-0.0522*(V(a12i25)))+(-0*(V(a12r25)))+(0.1344*(V(a12r24)-2*V(a12r25)+V(a12r26)))+(-0.01*((V(a4r25))*(V(a4r25))+(V(a4i25))*(V(a4i25))+(V(a8r25))*(V(a8r25))+(V(a8i25))*(V(a8i25))+(V(a12r25))*(V(a12r25))+(V(a12i25))*(V(a12i25)))*(V(a12i25)))+(0.17825*((((V(a4r25))*(V(a8i25))+(V(a4i25))*(V(a8r25))))*cos((-19.3548387097+-3.71*time))-(((V(a4r25))*(V(a8r25))-(V(a4i25))*(V(a8i25))))*sin((-19.3548387097+-3.71*time))))))}

Ca4r26 a4r26 0 1 ic=0
Ra4r26 a4r26 0 1e12
Ca4i26 a4i26 0 1 ic=0
Ra4i26 a4i26 0 1e12
Ca8r26 a8r26 0 1 ic=0
Ra8r26 a8r26 0 1e12
Ca8i26 a8i26 0 1 ic=0
Ra8i26 a8i26 0 1e12
Ca12r26 a12r26 0 1 ic=0
Ra12r26 a12r26 0 1e12
Ca12i26 a12i26 0 1 ic=0
Ra12i26 a12i26 0 1e12
B4r26 a4r26 0 I={-(((-0.045*(V(a4r26)))+(-0.16*(V(a4i25)-2*V(a4i26)+V(a4i27)))+(-0.01*((V(a4r26))*(V(a4r26))+(V(a4i26))*(V(a4i26))+(V(a8r26))*(V(a8r26))+(V(a8i26))*(V(a8i26))+(V(a12r26))*(V(a12r26))+(V(a12i26))*(V(a12i26)))*(V(a4r26)))))}
B4i26 a4i26 0 I={-(((-0.045*(V(a4i26)))+(0.16*(V(a4r25)-2*V(a4r26)+V(a4r27)))+(-0.01*((V(a4r26))*(V(a4r26))+(V(a4i26))*(V(a4i26))+(V(a8r26))*(V(a8r26))+(V(a8i26))*(V(a8i26))+(V(a12r26))*(V(a12r26))+(V(a12i26))*(V(a12i26)))*(V(a4i26)))))}
B8r26 a8r26 0 I={-(((-0.0486*(V(a8r26)))+(0*(V(a8i26)))+(-0.1472*(V(a8i25)-2*V(a8i26)+V(a8i27)))+(-0.01*((V(a4r26))*(V(a4r26))+(V(a4i26))*(V(a4i26))+(V(a8r26))*(V(a8r26))+(V(a8i26))*(V(a8i26))+(V(a12r26))*(V(a12r26))+(V(a12i26))*(V(a12i26)))*(V(a8r26)))+(0.13175*((((V(a4r26))*(V(a4r26))-(V(a4i26))*(V(a4i26))))*cos((20.1290322581+1.93*time))+((2*(V(a4r26))*(V(a4i26))))*sin((20.1290322581+1.93*time))))))}
B8i26 a8i26 0 I={-(((-0.0486*(V(a8i26)))+(-0*(V(a8r26)))+(0.1472*(V(a8r25)-2*V(a8r26)+V(a8r27)))+(-0.01*((V(a4r26))*(V(a4r26))+(V(a4i26))*(V(a4i26))+(V(a8r26))*(V(a8r26))+(V(a8i26))*(V(a8i26))+(V(a12r26))*(V(a12r26))+(V(a12i26))*(V(a12i26)))*(V(a8i26)))+(0.13175*(((2*(V(a4r26))*(V(a4i26))))*cos((20.1290322581+1.93*time))-(((V(a4r26))*(V(a4r26))-(V(a4i26))*(V(a4i26))))*sin((20.1290322581+1.93*time))))))}
B12r26 a12r26 0 I={-(((-0.0522*(V(a12r26)))+(0*(V(a12i26)))+(-0.1344*(V(a12i25)-2*V(a12i26)+V(a12i27)))+(-0.01*((V(a4r26))*(V(a4r26))+(V(a4i26))*(V(a4i26))+(V(a8r26))*(V(a8r26))+(V(a8i26))*(V(a8i26))+(V(a12r26))*(V(a12r26))+(V(a12i26))*(V(a12i26)))*(V(a12r26)))+(0.17825*((((V(a4r26))*(V(a8r26))-(V(a4i26))*(V(a8i26))))*cos((-20.1290322581+-3.71*time))+(((V(a4r26))*(V(a8i26))+(V(a4i26))*(V(a8r26))))*sin((-20.1290322581+-3.71*time))))))}
B12i26 a12i26 0 I={-(((-0.0522*(V(a12i26)))+(-0*(V(a12r26)))+(0.1344*(V(a12r25)-2*V(a12r26)+V(a12r27)))+(-0.01*((V(a4r26))*(V(a4r26))+(V(a4i26))*(V(a4i26))+(V(a8r26))*(V(a8r26))+(V(a8i26))*(V(a8i26))+(V(a12r26))*(V(a12r26))+(V(a12i26))*(V(a12i26)))*(V(a12i26)))+(0.17825*((((V(a4r26))*(V(a8i26))+(V(a4i26))*(V(a8r26))))*cos((-20.1290322581+-3.71*time))-(((V(a4r26))*(V(a8r26))-(V(a4i26))*(V(a8i26))))*sin((-20.1290322581+-3.71*time))))))}

Ca4r27 a4r27 0 1 ic=0
Ra4r27 a4r27 0 1e12
Ca4i27 a4i27 0 1 ic=0
Ra4i27 a4i27 0 1e12
Ca8r27 a8r27 0 1 ic=0
Ra8r27 a8r27 0 1e12
Ca8i27 a8i27 0 1 ic=0
Ra8i27 a8i27 0 1e12
Ca12r27 a12r27 0 1 ic=0
Ra12r27 a12r27 0 1e12
Ca12i27 a12i27 0 1 ic=0
Ra12i27 a12i27 0 1e12
B4r27 a4r27 0 I={-(((-0.045*(V(a4r27)))+(-0.16*(V(a4i26)-2*V(a4i27)+V(a4i28)))+(-0.01*((V(a4r27))*(V(a4r27))+(V(a4i27))*(V(a4i27))+(V(a8r27))*(V(a8r27))+(V(a8i27))*(V(a8i27))+(V(a12r27))*(V(a12r27))+(V(a12i27))*(V(a12i27)))*(V(a4r27)))))}
B4i27 a4i27 0 I={-(((-0.045*(V(a4i27)))+(0.16*(V(a4r26)-2*V(a4r27)+V(a4r28)))+(-0.01*((V(a4r27))*(V(a4r27))+(V(a4i27))*(V(a4i27))+(V(a8r27))*(V(a8r27))+(V(a8i27))*(V(a8i27))+(V(a12r27))*(V(a12r27))+(V(a12i27))*(V(a12i27)))*(V(a4i27)))))}
B8r27 a8r27 0 I={-(((-0.0486*(V(a8r27)))+(0*(V(a8i27)))+(-0.1472*(V(a8i26)-2*V(a8i27)+V(a8i28)))+(-0.01*((V(a4r27))*(V(a4r27))+(V(a4i27))*(V(a4i27))+(V(a8r27))*(V(a8r27))+(V(a8i27))*(V(a8i27))+(V(a12r27))*(V(a12r27))+(V(a12i27))*(V(a12i27)))*(V(a8r27)))+(0.13175*((((V(a4r27))*(V(a4r27))-(V(a4i27))*(V(a4i27))))*cos((20.9032258065+1.93*time))+((2*(V(a4r27))*(V(a4i27))))*sin((20.9032258065+1.93*time))))))}
B8i27 a8i27 0 I={-(((-0.0486*(V(a8i27)))+(-0*(V(a8r27)))+(0.1472*(V(a8r26)-2*V(a8r27)+V(a8r28)))+(-0.01*((V(a4r27))*(V(a4r27))+(V(a4i27))*(V(a4i27))+(V(a8r27))*(V(a8r27))+(V(a8i27))*(V(a8i27))+(V(a12r27))*(V(a12r27))+(V(a12i27))*(V(a12i27)))*(V(a8i27)))+(0.13175*(((2*(V(a4r27))*(V(a4i27))))*cos((20.9032258065+1.93*time))-(((V(a4r27))*(V(a4r27))-(V(a4i27))*(V(a4i27))))*sin((20.9032258065+1.93*time))))))}
B12r27 a12r27 0 I={-(((-0.0522*(V(a12r27)))+(0*(V(a12i27)))+(-0.1344*(V(a12i26)-2*V(a12i27)+V(a12i28)))+(-0.01*((V(a4r27))*(V(a4r27))+(V(a4i27))*(V(a4i27))+(V(a8r27))*(V(a8r27))+(V(a8i27))*(V(a8i27))+(V(a12r27))*(V(a12r27))+(V(a12i27))*(V(a12i27)))*(V(a12r27)))+(0.17825*((((V(a4r27))*(V(a8r27))-(V(a4i27))*(V(a8i27))))*cos((-20.9032258065+-3.71*time))+(((V(a4r27))*(V(a8i27))+(V(a4i27))*(V(a8r27))))*sin((-20.9032258065+-3.71*time))))))}
B12i27 a12i27 0 I={-(((-0.0522*(V(a12i27)))+(-0*(V(a12r27)))+(0.1344*(V(a12r26)-2*V(a12r27)+V(a12r28)))+(-0.01*((V(a4r27))*(V(a4r27))+(V(a4i27))*(V(a4i27))+(V(a8r27))*(V(a8r27))+(V(a8i27))*(V(a8i27))+(V(a12r27))*(V(a12r27))+(V(a12i27))*(V(a12i27)))*(V(a12i27)))+(0.17825*((((V(a4r27))*(V(a8i27))+(V(a4i27))*(V(a8r27))))*cos((-20.9032258065+-3.71*time))-(((V(a4r27))*(V(a8r27))-(V(a4i27))*(V(a8i27))))*sin((-20.9032258065+-3.71*time))))))}

Ca4r28 a4r28 0 1 ic=0
Ra4r28 a4r28 0 1e12
Ca4i28 a4i28 0 1 ic=0
Ra4i28 a4i28 0 1e12
Ca8r28 a8r28 0 1 ic=0
Ra8r28 a8r28 0 1e12
Ca8i28 a8i28 0 1 ic=0
Ra8i28 a8i28 0 1e12
Ca12r28 a12r28 0 1 ic=0
Ra12r28 a12r28 0 1e12
Ca12i28 a12i28 0 1 ic=0
Ra12i28 a12i28 0 1e12
B4r28 a4r28 0 I={-(((-0.045*(V(a4r28)))+(-0.16*(V(a4i27)-2*V(a4i28)+V(a4i29)))+(-0.01*((V(a4r28))*(V(a4r28))+(V(a4i28))*(V(a4i28))+(V(a8r28))*(V(a8r28))+(V(a8i28))*(V(a8i28))+(V(a12r28))*(V(a12r28))+(V(a12i28))*(V(a12i28)))*(V(a4r28)))))}
B4i28 a4i28 0 I={-(((-0.045*(V(a4i28)))+(0.16*(V(a4r27)-2*V(a4r28)+V(a4r29)))+(-0.01*((V(a4r28))*(V(a4r28))+(V(a4i28))*(V(a4i28))+(V(a8r28))*(V(a8r28))+(V(a8i28))*(V(a8i28))+(V(a12r28))*(V(a12r28))+(V(a12i28))*(V(a12i28)))*(V(a4i28)))))}
B8r28 a8r28 0 I={-(((-0.0486*(V(a8r28)))+(0*(V(a8i28)))+(-0.1472*(V(a8i27)-2*V(a8i28)+V(a8i29)))+(-0.01*((V(a4r28))*(V(a4r28))+(V(a4i28))*(V(a4i28))+(V(a8r28))*(V(a8r28))+(V(a8i28))*(V(a8i28))+(V(a12r28))*(V(a12r28))+(V(a12i28))*(V(a12i28)))*(V(a8r28)))+(0.13175*((((V(a4r28))*(V(a4r28))-(V(a4i28))*(V(a4i28))))*cos((21.6774193548+1.93*time))+((2*(V(a4r28))*(V(a4i28))))*sin((21.6774193548+1.93*time))))))}
B8i28 a8i28 0 I={-(((-0.0486*(V(a8i28)))+(-0*(V(a8r28)))+(0.1472*(V(a8r27)-2*V(a8r28)+V(a8r29)))+(-0.01*((V(a4r28))*(V(a4r28))+(V(a4i28))*(V(a4i28))+(V(a8r28))*(V(a8r28))+(V(a8i28))*(V(a8i28))+(V(a12r28))*(V(a12r28))+(V(a12i28))*(V(a12i28)))*(V(a8i28)))+(0.13175*(((2*(V(a4r28))*(V(a4i28))))*cos((21.6774193548+1.93*time))-(((V(a4r28))*(V(a4r28))-(V(a4i28))*(V(a4i28))))*sin((21.6774193548+1.93*time))))))}
B12r28 a12r28 0 I={-(((-0.0522*(V(a12r28)))+(0*(V(a12i28)))+(-0.1344*(V(a12i27)-2*V(a12i28)+V(a12i29)))+(-0.01*((V(a4r28))*(V(a4r28))+(V(a4i28))*(V(a4i28))+(V(a8r28))*(V(a8r28))+(V(a8i28))*(V(a8i28))+(V(a12r28))*(V(a12r28))+(V(a12i28))*(V(a12i28)))*(V(a12r28)))+(0.17825*((((V(a4r28))*(V(a8r28))-(V(a4i28))*(V(a8i28))))*cos((-21.6774193548+-3.71*time))+(((V(a4r28))*(V(a8i28))+(V(a4i28))*(V(a8r28))))*sin((-21.6774193548+-3.71*time))))))}
B12i28 a12i28 0 I={-(((-0.0522*(V(a12i28)))+(-0*(V(a12r28)))+(0.1344*(V(a12r27)-2*V(a12r28)+V(a12r29)))+(-0.01*((V(a4r28))*(V(a4r28))+(V(a4i28))*(V(a4i28))+(V(a8r28))*(V(a8r28))+(V(a8i28))*(V(a8i28))+(V(a12r28))*(V(a12r28))+(V(a12i28))*(V(a12i28)))*(V(a12i28)))+(0.17825*((((V(a4r28))*(V(a8i28))+(V(a4i28))*(V(a8r28))))*cos((-21.6774193548+-3.71*time))-(((V(a4r28))*(V(a8r28))-(V(a4i28))*(V(a8i28))))*sin((-21.6774193548+-3.71*time))))))}

Ca4r29 a4r29 0 1 ic=0
Ra4r29 a4r29 0 1e12
Ca4i29 a4i29 0 1 ic=0
Ra4i29 a4i29 0 1e12
Ca8r29 a8r29 0 1 ic=0
Ra8r29 a8r29 0 1e12
Ca8i29 a8i29 0 1 ic=0
Ra8i29 a8i29 0 1e12
Ca12r29 a12r29 0 1 ic=0
Ra12r29 a12r29 0 1e12
Ca12i29 a12i29 0 1 ic=0
Ra12i29 a12i29 0 1e12
B4r29 a4r29 0 I={-(((-0.045*(V(a4r29)))+(-0.16*(V(a4i28)-2*V(a4i29)+V(a4i30)))+(-0.01*((V(a4r29))*(V(a4r29))+(V(a4i29))*(V(a4i29))+(V(a8r29))*(V(a8r29))+(V(a8i29))*(V(a8i29))+(V(a12r29))*(V(a12r29))+(V(a12i29))*(V(a12i29)))*(V(a4r29)))))}
B4i29 a4i29 0 I={-(((-0.045*(V(a4i29)))+(0.16*(V(a4r28)-2*V(a4r29)+V(a4r30)))+(-0.01*((V(a4r29))*(V(a4r29))+(V(a4i29))*(V(a4i29))+(V(a8r29))*(V(a8r29))+(V(a8i29))*(V(a8i29))+(V(a12r29))*(V(a12r29))+(V(a12i29))*(V(a12i29)))*(V(a4i29)))))}
B8r29 a8r29 0 I={-(((-0.0486*(V(a8r29)))+(0*(V(a8i29)))+(-0.1472*(V(a8i28)-2*V(a8i29)+V(a8i30)))+(-0.01*((V(a4r29))*(V(a4r29))+(V(a4i29))*(V(a4i29))+(V(a8r29))*(V(a8r29))+(V(a8i29))*(V(a8i29))+(V(a12r29))*(V(a12r29))+(V(a12i29))*(V(a12i29)))*(V(a8r29)))+(0.13175*((((V(a4r29))*(V(a4r29))-(V(a4i29))*(V(a4i29))))*cos((22.4516129032+1.93*time))+((2*(V(a4r29))*(V(a4i29))))*sin((22.4516129032+1.93*time))))))}
B8i29 a8i29 0 I={-(((-0.0486*(V(a8i29)))+(-0*(V(a8r29)))+(0.1472*(V(a8r28)-2*V(a8r29)+V(a8r30)))+(-0.01*((V(a4r29))*(V(a4r29))+(V(a4i29))*(V(a4i29))+(V(a8r29))*(V(a8r29))+(V(a8i29))*(V(a8i29))+(V(a12r29))*(V(a12r29))+(V(a12i29))*(V(a12i29)))*(V(a8i29)))+(0.13175*(((2*(V(a4r29))*(V(a4i29))))*cos((22.4516129032+1.93*time))-(((V(a4r29))*(V(a4r29))-(V(a4i29))*(V(a4i29))))*sin((22.4516129032+1.93*time))))))}
B12r29 a12r29 0 I={-(((-0.0522*(V(a12r29)))+(0*(V(a12i29)))+(-0.1344*(V(a12i28)-2*V(a12i29)+V(a12i30)))+(-0.01*((V(a4r29))*(V(a4r29))+(V(a4i29))*(V(a4i29))+(V(a8r29))*(V(a8r29))+(V(a8i29))*(V(a8i29))+(V(a12r29))*(V(a12r29))+(V(a12i29))*(V(a12i29)))*(V(a12r29)))+(0.17825*((((V(a4r29))*(V(a8r29))-(V(a4i29))*(V(a8i29))))*cos((-22.4516129032+-3.71*time))+(((V(a4r29))*(V(a8i29))+(V(a4i29))*(V(a8r29))))*sin((-22.4516129032+-3.71*time))))))}
B12i29 a12i29 0 I={-(((-0.0522*(V(a12i29)))+(-0*(V(a12r29)))+(0.1344*(V(a12r28)-2*V(a12r29)+V(a12r30)))+(-0.01*((V(a4r29))*(V(a4r29))+(V(a4i29))*(V(a4i29))+(V(a8r29))*(V(a8r29))+(V(a8i29))*(V(a8i29))+(V(a12r29))*(V(a12r29))+(V(a12i29))*(V(a12i29)))*(V(a12i29)))+(0.17825*((((V(a4r29))*(V(a8i29))+(V(a4i29))*(V(a8r29))))*cos((-22.4516129032+-3.71*time))-(((V(a4r29))*(V(a8r29))-(V(a4i29))*(V(a8i29))))*sin((-22.4516129032+-3.71*time))))))}

Ca4r30 a4r30 0 1 ic=0
Ra4r30 a4r30 0 1e12
Ca4i30 a4i30 0 1 ic=0
Ra4i30 a4i30 0 1e12
Ca8r30 a8r30 0 1 ic=0
Ra8r30 a8r30 0 1e12
Ca8i30 a8i30 0 1 ic=0
Ra8i30 a8i30 0 1e12
Ca12r30 a12r30 0 1 ic=0
Ra12r30 a12r30 0 1e12
Ca12i30 a12i30 0 1 ic=0
Ra12i30 a12i30 0 1e12
B4r30 a4r30 0 I={-(((-0.045*(V(a4r30)))+(-0.16*(V(a4i29)-2*V(a4i30)+V(a4i31)))+(-0.01*((V(a4r30))*(V(a4r30))+(V(a4i30))*(V(a4i30))+(V(a8r30))*(V(a8r30))+(V(a8i30))*(V(a8i30))+(V(a12r30))*(V(a12r30))+(V(a12i30))*(V(a12i30)))*(V(a4r30)))))}
B4i30 a4i30 0 I={-(((-0.045*(V(a4i30)))+(0.16*(V(a4r29)-2*V(a4r30)+V(a4r31)))+(-0.01*((V(a4r30))*(V(a4r30))+(V(a4i30))*(V(a4i30))+(V(a8r30))*(V(a8r30))+(V(a8i30))*(V(a8i30))+(V(a12r30))*(V(a12r30))+(V(a12i30))*(V(a12i30)))*(V(a4i30)))))}
B8r30 a8r30 0 I={-(((-0.0486*(V(a8r30)))+(0*(V(a8i30)))+(-0.1472*(V(a8i29)-2*V(a8i30)+V(a8i31)))+(-0.01*((V(a4r30))*(V(a4r30))+(V(a4i30))*(V(a4i30))+(V(a8r30))*(V(a8r30))+(V(a8i30))*(V(a8i30))+(V(a12r30))*(V(a12r30))+(V(a12i30))*(V(a12i30)))*(V(a8r30)))+(0.13175*((((V(a4r30))*(V(a4r30))-(V(a4i30))*(V(a4i30))))*cos((23.2258064516+1.93*time))+((2*(V(a4r30))*(V(a4i30))))*sin((23.2258064516+1.93*time))))))}
B8i30 a8i30 0 I={-(((-0.0486*(V(a8i30)))+(-0*(V(a8r30)))+(0.1472*(V(a8r29)-2*V(a8r30)+V(a8r31)))+(-0.01*((V(a4r30))*(V(a4r30))+(V(a4i30))*(V(a4i30))+(V(a8r30))*(V(a8r30))+(V(a8i30))*(V(a8i30))+(V(a12r30))*(V(a12r30))+(V(a12i30))*(V(a12i30)))*(V(a8i30)))+(0.13175*(((2*(V(a4r30))*(V(a4i30))))*cos((23.2258064516+1.93*time))-(((V(a4r30))*(V(a4r30))-(V(a4i30))*(V(a4i30))))*sin((23.2258064516+1.93*time))))))}
B12r30 a12r30 0 I={-(((-0.0522*(V(a12r30)))+(0*(V(a12i30)))+(-0.1344*(V(a12i29)-2*V(a12i30)+V(a12i31)))+(-0.01*((V(a4r30))*(V(a4r30))+(V(a4i30))*(V(a4i30))+(V(a8r30))*(V(a8r30))+(V(a8i30))*(V(a8i30))+(V(a12r30))*(V(a12r30))+(V(a12i30))*(V(a12i30)))*(V(a12r30)))+(0.17825*((((V(a4r30))*(V(a8r30))-(V(a4i30))*(V(a8i30))))*cos((-23.2258064516+-3.71*time))+(((V(a4r30))*(V(a8i30))+(V(a4i30))*(V(a8r30))))*sin((-23.2258064516+-3.71*time))))))}
B12i30 a12i30 0 I={-(((-0.0522*(V(a12i30)))+(-0*(V(a12r30)))+(0.1344*(V(a12r29)-2*V(a12r30)+V(a12r31)))+(-0.01*((V(a4r30))*(V(a4r30))+(V(a4i30))*(V(a4i30))+(V(a8r30))*(V(a8r30))+(V(a8i30))*(V(a8i30))+(V(a12r30))*(V(a12r30))+(V(a12i30))*(V(a12i30)))*(V(a12i30)))+(0.17825*((((V(a4r30))*(V(a8i30))+(V(a4i30))*(V(a8r30))))*cos((-23.2258064516+-3.71*time))-(((V(a4r30))*(V(a8r30))-(V(a4i30))*(V(a8i30))))*sin((-23.2258064516+-3.71*time))))))}

Ca4r31 a4r31 0 1 ic=0
Ra4r31 a4r31 0 1e12
Ca4i31 a4i31 0 1 ic=0
Ra4i31 a4i31 0 1e12
Ca8r31 a8r31 0 1 ic=0
Ra8r31 a8r31 0 1e12
Ca8i31 a8i31 0 1 ic=0
Ra8i31 a8i31 0 1e12
Ca12r31 a12r31 0 1 ic=0
Ra12r31 a12r31 0 1e12
Ca12i31 a12i31 0 1 ic=0
Ra12i31 a12i31 0 1e12
B4r31 a4r31 0 I={-(((-0.045*(V(a4r31)))+(-0.16*(V(a4i30)-V(a4i31)))+(-0.01*((V(a4r31))*(V(a4r31))+(V(a4i31))*(V(a4i31))+(V(a8r31))*(V(a8r31))+(V(a8i31))*(V(a8i31))+(V(a12r31))*(V(a12r31))+(V(a12i31))*(V(a12i31)))*(V(a4r31)))))}
B4i31 a4i31 0 I={-(((-0.045*(V(a4i31)))+(0.16*(V(a4r30)-V(a4r31)))+(-0.01*((V(a4r31))*(V(a4r31))+(V(a4i31))*(V(a4i31))+(V(a8r31))*(V(a8r31))+(V(a8i31))*(V(a8i31))+(V(a12r31))*(V(a12r31))+(V(a12i31))*(V(a12i31)))*(V(a4i31)))))}
B8r31 a8r31 0 I={-(((-0.0486*(V(a8r31)))+(0*(V(a8i31)))+(-0.1472*(V(a8i30)-V(a8i31)))+(-0.01*((V(a4r31))*(V(a4r31))+(V(a4i31))*(V(a4i31))+(V(a8r31))*(V(a8r31))+(V(a8i31))*(V(a8i31))+(V(a12r31))*(V(a12r31))+(V(a12i31))*(V(a12i31)))*(V(a8r31)))+(0.13175*((((V(a4r31))*(V(a4r31))-(V(a4i31))*(V(a4i31))))*cos((24+1.93*time))+((2*(V(a4r31))*(V(a4i31))))*sin((24+1.93*time))))))}
B8i31 a8i31 0 I={-(((-0.0486*(V(a8i31)))+(-0*(V(a8r31)))+(0.1472*(V(a8r30)-V(a8r31)))+(-0.01*((V(a4r31))*(V(a4r31))+(V(a4i31))*(V(a4i31))+(V(a8r31))*(V(a8r31))+(V(a8i31))*(V(a8i31))+(V(a12r31))*(V(a12r31))+(V(a12i31))*(V(a12i31)))*(V(a8i31)))+(0.13175*(((2*(V(a4r31))*(V(a4i31))))*cos((24+1.93*time))-(((V(a4r31))*(V(a4r31))-(V(a4i31))*(V(a4i31))))*sin((24+1.93*time))))))}
B12r31 a12r31 0 I={-(((-0.0522*(V(a12r31)))+(0*(V(a12i31)))+(-0.1344*(V(a12i30)-V(a12i31)))+(-0.01*((V(a4r31))*(V(a4r31))+(V(a4i31))*(V(a4i31))+(V(a8r31))*(V(a8r31))+(V(a8i31))*(V(a8i31))+(V(a12r31))*(V(a12r31))+(V(a12i31))*(V(a12i31)))*(V(a12r31)))+(0.17825*((((V(a4r31))*(V(a8r31))-(V(a4i31))*(V(a8i31))))*cos((-24+-3.71*time))+(((V(a4r31))*(V(a8i31))+(V(a4i31))*(V(a8r31))))*sin((-24+-3.71*time))))))}
B12i31 a12i31 0 I={-(((-0.0522*(V(a12i31)))+(-0*(V(a12r31)))+(0.1344*(V(a12r30)-V(a12r31)))+(-0.01*((V(a4r31))*(V(a4r31))+(V(a4i31))*(V(a4i31))+(V(a8r31))*(V(a8r31))+(V(a8i31))*(V(a8i31))+(V(a12r31))*(V(a12r31))+(V(a12i31))*(V(a12i31)))*(V(a12i31)))+(0.17825*((((V(a4r31))*(V(a8i31))+(V(a4i31))*(V(a8r31))))*cos((-24+-3.71*time))-(((V(a4r31))*(V(a8r31))-(V(a4i31))*(V(a8i31))))*sin((-24+-3.71*time))))))}

Bobs4r obs4r 0 V={(3.60541118673e-06*V(a4r0)+6.94606240843e-06*V(a4r1)+1.30974088209e-05*V(a4r2)+2.41710162372e-05*V(a4r3)+4.36583441612e-05*V(a4r4)+7.71795840655e-05*V(a4r5)+0.000133536635865*V(a4r6)+0.000226131598091*V(a4r7)+0.000374787326302*V(a4r8)+0.000607954902147*V(a4r9)+0.000965207430274*V(a4r10)+0.00149979800631*V(a4r11)+0.00228090769857*V(a4r12)+0.00339504452095*V(a4r13)+0.00494590830132*V(a4r14)+0.00705195399059*V(a4r15)+0.0098409200563*V(a4r16)+0.0134407889282*V(a4r17)+0.017967044439*V(a4r18)+0.0235066827753*V(a4r19)+0.0301001648913*V(a4r20)+0.0377232608352*V(a4r21)+0.0462713746585*V(a4r22)+0.05554927576*V(a4r23)+0.0652690398216*V(a4r24)+0.0750583252914*V(a4r25)+0.0844798900902*V(a4r26)+0.0930616254469*V(a4r27)+0.100334606342*V(a4r28)+0.105875065492*V(a4r29)+0.10934513284*V(a4r30)+0.110526914094*V(a4r31))}
Bobs4i obs4i 0 V={(3.60541118673e-06*V(a4i0)+6.94606240843e-06*V(a4i1)+1.30974088209e-05*V(a4i2)+2.41710162372e-05*V(a4i3)+4.36583441612e-05*V(a4i4)+7.71795840655e-05*V(a4i5)+0.000133536635865*V(a4i6)+0.000226131598091*V(a4i7)+0.000374787326302*V(a4i8)+0.000607954902147*V(a4i9)+0.000965207430274*V(a4i10)+0.00149979800631*V(a4i11)+0.00228090769857*V(a4i12)+0.00339504452095*V(a4i13)+0.00494590830132*V(a4i14)+0.00705195399059*V(a4i15)+0.0098409200563*V(a4i16)+0.0134407889282*V(a4i17)+0.017967044439*V(a4i18)+0.0235066827753*V(a4i19)+0.0301001648913*V(a4i20)+0.0377232608352*V(a4i21)+0.0462713746585*V(a4i22)+0.05554927576*V(a4i23)+0.0652690398216*V(a4i24)+0.0750583252914*V(a4i25)+0.0844798900902*V(a4i26)+0.0930616254469*V(a4i27)+0.100334606342*V(a4i28)+0.105875065492*V(a4i29)+0.10934513284*V(a4i30)+0.110526914094*V(a4i31))}
Bobs8r obs8r 0 V={(3.60541118673e-06*V(a8r0)+6.94606240843e-06*V(a8r1)+1.30974088209e-05*V(a8r2)+2.41710162372e-05*V(a8r3)+4.36583441612e-05*V(a8r4)+7.71795840655e-05*V(a8r5)+0.000133536635865*V(a8r6)+0.000226131598091*V(a8r7)+0.000374787326302*V(a8r8)+0.000607954902147*V(a8r9)+0.000965207430274*V(a8r10)+0.00149979800631*V(a8r11)+0.00228090769857*V(a8r12)+0.00339504452095*V(a8r13)+0.00494590830132*V(a8r14)+0.00705195399059*V(a8r15)+0.0098409200563*V(a8r16)+0.0134407889282*V(a8r17)+0.017967044439*V(a8r18)+0.0235066827753*V(a8r19)+0.0301001648913*V(a8r20)+0.0377232608352*V(a8r21)+0.0462713746585*V(a8r22)+0.05554927576*V(a8r23)+0.0652690398216*V(a8r24)+0.0750583252914*V(a8r25)+0.0844798900902*V(a8r26)+0.0930616254469*V(a8r27)+0.100334606342*V(a8r28)+0.105875065492*V(a8r29)+0.10934513284*V(a8r30)+0.110526914094*V(a8r31))}
Bobs8i obs8i 0 V={(3.60541118673e-06*V(a8i0)+6.94606240843e-06*V(a8i1)+1.30974088209e-05*V(a8i2)+2.41710162372e-05*V(a8i3)+4.36583441612e-05*V(a8i4)+7.71795840655e-05*V(a8i5)+0.000133536635865*V(a8i6)+0.000226131598091*V(a8i7)+0.000374787326302*V(a8i8)+0.000607954902147*V(a8i9)+0.000965207430274*V(a8i10)+0.00149979800631*V(a8i11)+0.00228090769857*V(a8i12)+0.00339504452095*V(a8i13)+0.00494590830132*V(a8i14)+0.00705195399059*V(a8i15)+0.0098409200563*V(a8i16)+0.0134407889282*V(a8i17)+0.017967044439*V(a8i18)+0.0235066827753*V(a8i19)+0.0301001648913*V(a8i20)+0.0377232608352*V(a8i21)+0.0462713746585*V(a8i22)+0.05554927576*V(a8i23)+0.0652690398216*V(a8i24)+0.0750583252914*V(a8i25)+0.0844798900902*V(a8i26)+0.0930616254469*V(a8i27)+0.100334606342*V(a8i28)+0.105875065492*V(a8i29)+0.10934513284*V(a8i30)+0.110526914094*V(a8i31))}
Bobs12r obs12r 0 V={(3.60541118673e-06*V(a12r0)+6.94606240843e-06*V(a12r1)+1.30974088209e-05*V(a12r2)+2.41710162372e-05*V(a12r3)+4.36583441612e-05*V(a12r4)+7.71795840655e-05*V(a12r5)+0.000133536635865*V(a12r6)+0.000226131598091*V(a12r7)+0.000374787326302*V(a12r8)+0.000607954902147*V(a12r9)+0.000965207430274*V(a12r10)+0.00149979800631*V(a12r11)+0.00228090769857*V(a12r12)+0.00339504452095*V(a12r13)+0.00494590830132*V(a12r14)+0.00705195399059*V(a12r15)+0.0098409200563*V(a12r16)+0.0134407889282*V(a12r17)+0.017967044439*V(a12r18)+0.0235066827753*V(a12r19)+0.0301001648913*V(a12r20)+0.0377232608352*V(a12r21)+0.0462713746585*V(a12r22)+0.05554927576*V(a12r23)+0.0652690398216*V(a12r24)+0.0750583252914*V(a12r25)+0.0844798900902*V(a12r26)+0.0930616254469*V(a12r27)+0.100334606342*V(a12r28)+0.105875065492*V(a12r29)+0.10934513284*V(a12r30)+0.110526914094*V(a12r31))}
Bobs12i obs12i 0 V={(3.60541118673e-06*V(a12i0)+6.94606240843e-06*V(a12i1)+1.30974088209e-05*V(a12i2)+2.41710162372e-05*V(a12i3)+4.36583441612e-05*V(a12i4)+7.71795840655e-05*V(a12i5)+0.000133536635865*V(a12i6)+0.000226131598091*V(a12i7)+0.000374787326302*V(a12i8)+0.000607954902147*V(a12i9)+0.000965207430274*V(a12i10)+0.00149979800631*V(a12i11)+0.00228090769857*V(a12i12)+0.00339504452095*V(a12i13)+0.00494590830132*V(a12i14)+0.00705195399059*V(a12i15)+0.0098409200563*V(a12i16)+0.0134407889282*V(a12i17)+0.017967044439*V(a12i18)+0.0235066827753*V(a12i19)+0.0301001648913*V(a12i20)+0.0377232608352*V(a12i21)+0.0462713746585*V(a12i22)+0.05554927576*V(a12i23)+0.0652690398216*V(a12i24)+0.0750583252914*V(a12i25)+0.0844798900902*V(a12i26)+0.0930616254469*V(a12i27)+0.100334606342*V(a12i28)+0.105875065492*V(a12i29)+0.10934513284*V(a12i30)+0.110526914094*V(a12i31))}

.control
set noaskquit
set filetype=ascii
tran 0.04 96 0 0.04 uic
wrdata shuffled_frequency_control_tran.csv v(obs4r) v(obs4i) v(obs8r) v(obs8i) v(obs12r) v(obs12i) v(a4r0) v(a4i0) v(a8r0) v(a8i0) v(a12r0) v(a12i0) v(a4r1) v(a4i1) v(a8r1) v(a8i1) v(a12r1) v(a12i1) v(a4r2) v(a4i2) v(a8r2) v(a8i2) v(a12r2) v(a12i2) v(a4r3) v(a4i3) v(a8r3) v(a8i3) v(a12r3) v(a12i3) v(a4r4) v(a4i4) v(a8r4) v(a8i4) v(a12r4) v(a12i4) v(a4r5) v(a4i5) v(a8r5) v(a8i5) v(a12r5) v(a12i5) v(a4r6) v(a4i6) v(a8r6) v(a8i6) v(a12r6) v(a12i6) v(a4r7) v(a4i7) v(a8r7) v(a8i7) v(a12r7) v(a12i7) v(a4r8) v(a4i8) v(a8r8) v(a8i8) v(a12r8) v(a12i8) v(a4r9) v(a4i9) v(a8r9) v(a8i9) v(a12r9) v(a12i9) v(a4r10) v(a4i10) v(a8r10) v(a8i10) v(a12r10) v(a12i10) v(a4r11) v(a4i11) v(a8r11) v(a8i11) v(a12r11) v(a12i11) v(a4r12) v(a4i12) v(a8r12) v(a8i12) v(a12r12) v(a12i12) v(a4r13) v(a4i13) v(a8r13) v(a8i13) v(a12r13) v(a12i13) v(a4r14) v(a4i14) v(a8r14) v(a8i14) v(a12r14) v(a12i14) v(a4r15) v(a4i15) v(a8r15) v(a8i15) v(a12r15) v(a12i15) v(a4r16) v(a4i16) v(a8r16) v(a8i16) v(a12r16) v(a12i16) v(a4r17) v(a4i17) v(a8r17) v(a8i17) v(a12r17) v(a12i17) v(a4r18) v(a4i18) v(a8r18) v(a8i18) v(a12r18) v(a12i18) v(a4r19) v(a4i19) v(a8r19) v(a8i19) v(a12r19) v(a12i19) v(a4r20) v(a4i20) v(a8r20) v(a8i20) v(a12r20) v(a12i20) v(a4r21) v(a4i21) v(a8r21) v(a8i21) v(a12r21) v(a12i21) v(a4r22) v(a4i22) v(a8r22) v(a8i22) v(a12r22) v(a12i22) v(a4r23) v(a4i23) v(a8r23) v(a8i23) v(a12r23) v(a12i23) v(a4r24) v(a4i24) v(a8r24) v(a8i24) v(a12r24) v(a12i24) v(a4r25) v(a4i25) v(a8r25) v(a8i25) v(a12r25) v(a12i25) v(a4r26) v(a4i26) v(a8r26) v(a8i26) v(a12r26) v(a12i26) v(a4r27) v(a4i27) v(a8r27) v(a8i27) v(a12r27) v(a12i27) v(a4r28) v(a4i28) v(a8r28) v(a8i28) v(a12r28) v(a12i28) v(a4r29) v(a4i29) v(a8r29) v(a8i29) v(a12r29) v(a12i29) v(a4r30) v(a4i30) v(a8r30) v(a8i30) v(a12r30) v(a12i30) v(a4r31) v(a4i31) v(a8r31) v(a8i31) v(a12r31) v(a12i31)
quit
.endc
.end

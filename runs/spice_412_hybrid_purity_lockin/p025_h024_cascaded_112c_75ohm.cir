* p025_h024_cascaded_112c_75ohm
* Hybrid purity lock-in: source-only 50 MHz, passive 150 MHz extraction.
* role=discovery; source_only=True; no direct 100/150 MHz discovery drive.
* extraction=cascaded; stages=2; q_label=medium
.option method=gear maxord=2 reltol=2e-4 abstol=1e-12 vntol=1e-6 chgtol=1e-16 itl4=320
.model DVAR D(Is=1e-15 Rs=0.3 Cjo=4.89870014811e-11 Vj=0.62 M=0.6 Bv=18 Ibv=1e-06)
.param kmag=1.19925e-06
.param gcore=1.35e-07
Vbias vb 0 DC 3.1
Vsrc src 0 SIN(0 2.6 50000000)
Rsrc src n0 75
Rrawload n112 0 300
Cbase0 n0 0 1.35920509936e-11
Rbleed0 n0 0 160000
Rser1 n0 ns1 0.0133191004764
Lser1 ns1 n1 7.64552868391e-08
Cfixed1 n1 0 2.44656917885e-12
Dvar1 n1 vb DVAR
Rbleed1 n1 0 160000
Rser2 n1 ns2 0.0133191004764
Lser2 ns2 n2 7.64552868391e-08
Cfixed2 n2 0 2.44656917885e-12
Dvar2 n2 vb DVAR
Rbleed2 n2 0 160000
Rser3 n2 ns3 0.0133191004764
Lser3 ns3 n3 7.64552868391e-08
Cfixed3 n3 0 2.44656917885e-12
Dvar3 n3 vb DVAR
Rbleed3 n3 0 160000
Rser4 n3 ns4 0.0133191004764
Lser4 ns4 n4 7.64552868391e-08
Cfixed4 n4 0 2.44656917885e-12
Dvar4 n4 vb DVAR
Rbleed4 n4 0 160000
Rser5 n4 ns5 0.0133191004764
Lser5 ns5 n5 7.64552868391e-08
Cfixed5 n5 0 2.44656917885e-12
Dvar5 n5 vb DVAR
Rbleed5 n5 0 160000
Rser6 n5 ns6 0.0133191004764
Lser6 ns6 n6 7.64552868391e-08
Cfixed6 n6 0 2.44656917885e-12
Dvar6 n6 vb DVAR
Rbleed6 n6 0 160000
Rser7 n6 ns7 0.0133191004764
Lser7 ns7 n7 7.64552868391e-08
Cfixed7 n7 0 2.44656917885e-12
Dvar7 n7 vb DVAR
Rbleed7 n7 0 160000
Rser8 n7 ns8 0.0133191004764
Lser8 ns8 n8 7.64552868391e-08
Cfixed8 n8 0 2.44656917885e-12
Dvar8 n8 vb DVAR
Rbleed8 n8 0 160000
Rser9 n8 ns9 0.0133191004764
Lser9 ns9 n9 7.64552868391e-08
Cfixed9 n9 0 2.44656917885e-12
Dvar9 n9 vb DVAR
Rbleed9 n9 0 160000
Rser10 n9 ns10 0.0133191004764
Lser10 ns10 n10 7.64552868391e-08
Cfixed10 n10 0 2.44656917885e-12
Dvar10 n10 vb DVAR
Rbleed10 n10 0 160000
Rser11 n10 ns11 0.0133191004764
Lser11 ns11 n11 7.64552868391e-08
Cfixed11 n11 0 2.44656917885e-12
Dvar11 n11 vb DVAR
Rbleed11 n11 0 160000
Rser12 n11 ns12 0.0133191004764
Lser12 ns12 n12 7.64552868391e-08
Cfixed12 n12 0 2.44656917885e-12
Dvar12 n12 vb DVAR
Rbleed12 n12 0 160000
Rser13 n12 ns13 0.0133191004764
Lser13 ns13 n13 7.64552868391e-08
Cfixed13 n13 0 2.44656917885e-12
Dvar13 n13 vb DVAR
Rbleed13 n13 0 160000
Rser14 n13 ns14 0.0133191004764
Lser14 ns14 n14 7.64552868391e-08
Cfixed14 n14 0 2.44656917885e-12
Dvar14 n14 vb DVAR
Rbleed14 n14 0 160000
Rser15 n14 ns15 0.0133191004764
Lser15 ns15 n15 7.64552868391e-08
Cfixed15 n15 0 2.44656917885e-12
Dvar15 n15 vb DVAR
Rbleed15 n15 0 160000
Rser16 n15 ns16 0.0133191004764
Lser16 ns16 n16 7.64552868391e-08
Cfixed16 n16 0 2.44656917885e-12
Dvar16 n16 vb DVAR
Rbleed16 n16 0 160000
Rser17 n16 ns17 0.0133191004764
Lser17 ns17 n17 7.64552868391e-08
Cfixed17 n17 0 2.44656917885e-12
Dvar17 n17 vb DVAR
Rbleed17 n17 0 160000
Rser18 n17 ns18 0.0133191004764
Lser18 ns18 n18 7.64552868391e-08
Cfixed18 n18 0 2.44656917885e-12
Dvar18 n18 vb DVAR
Rbleed18 n18 0 160000
Rser19 n18 ns19 0.0133191004764
Lser19 ns19 n19 7.64552868391e-08
Cfixed19 n19 0 2.44656917885e-12
Dvar19 n19 vb DVAR
Rbleed19 n19 0 160000
Rser20 n19 ns20 0.0133191004764
Lser20 ns20 n20 7.64552868391e-08
Cfixed20 n20 0 2.44656917885e-12
Dvar20 n20 vb DVAR
Rbleed20 n20 0 160000
Rser21 n20 ns21 0.0133191004764
Lser21 ns21 n21 7.64552868391e-08
Cfixed21 n21 0 2.44656917885e-12
Dvar21 n21 vb DVAR
Rbleed21 n21 0 160000
Rser22 n21 ns22 0.0133191004764
Lser22 ns22 n22 7.64552868391e-08
Cfixed22 n22 0 2.44656917885e-12
Dvar22 n22 vb DVAR
Rbleed22 n22 0 160000
Rser23 n22 ns23 0.0133191004764
Lser23 ns23 n23 7.64552868391e-08
Cfixed23 n23 0 2.44656917885e-12
Dvar23 n23 vb DVAR
Rbleed23 n23 0 160000
Rser24 n23 ns24 0.0133191004764
Lser24 ns24 n24 7.64552868391e-08
Cfixed24 n24 0 2.44656917885e-12
Dvar24 n24 vb DVAR
Rbleed24 n24 0 160000
Rser25 n24 ns25 0.0133191004764
Lser25 ns25 n25 7.64552868391e-08
Cfixed25 n25 0 2.44656917885e-12
Dvar25 n25 vb DVAR
Rbleed25 n25 0 160000
Rser26 n25 ns26 0.0133191004764
Lser26 ns26 n26 7.64552868391e-08
Cfixed26 n26 0 2.44656917885e-12
Dvar26 n26 vb DVAR
Rbleed26 n26 0 160000
Rser27 n26 ns27 0.0133191004764
Lser27 ns27 n27 7.64552868391e-08
Cfixed27 n27 0 2.44656917885e-12
Dvar27 n27 vb DVAR
Rbleed27 n27 0 160000
Rser28 n27 ns28 0.0133191004764
Lser28 ns28 n28 7.64552868391e-08
Cfixed28 n28 0 2.44656917885e-12
Dvar28 n28 vb DVAR
Rbleed28 n28 0 160000
Rser29 n28 ns29 0.0133191004764
Lser29 ns29 n29 7.64552868391e-08
Cfixed29 n29 0 2.44656917885e-12
Dvar29 n29 vb DVAR
Rbleed29 n29 0 160000
Rser30 n29 ns30 0.0133191004764
Lser30 ns30 n30 7.64552868391e-08
Cfixed30 n30 0 2.44656917885e-12
Dvar30 n30 vb DVAR
Rbleed30 n30 0 160000
Rser31 n30 ns31 0.0133191004764
Lser31 ns31 n31 7.64552868391e-08
Cfixed31 n31 0 2.44656917885e-12
Dvar31 n31 vb DVAR
Rbleed31 n31 0 160000
Rser32 n31 ns32 0.0133191004764
Lser32 ns32 n32 7.64552868391e-08
Cfixed32 n32 0 2.44656917885e-12
Dvar32 n32 vb DVAR
Rbleed32 n32 0 160000
Rser33 n32 ns33 0.0133191004764
Lser33 ns33 n33 7.64552868391e-08
Cfixed33 n33 0 2.44656917885e-12
Dvar33 n33 vb DVAR
Rbleed33 n33 0 160000
Rser34 n33 ns34 0.0133191004764
Lser34 ns34 n34 7.64552868391e-08
Cfixed34 n34 0 2.44656917885e-12
Dvar34 n34 vb DVAR
Rbleed34 n34 0 160000
Rser35 n34 ns35 0.0133191004764
Lser35 ns35 n35 7.64552868391e-08
Cfixed35 n35 0 2.44656917885e-12
Dvar35 n35 vb DVAR
Rbleed35 n35 0 160000
Rser36 n35 ns36 0.0133191004764
Lser36 ns36 n36 7.64552868391e-08
Cfixed36 n36 0 2.44656917885e-12
Dvar36 n36 vb DVAR
Rbleed36 n36 0 160000
Rser37 n36 ns37 0.0133191004764
Lser37 ns37 n37 7.64552868391e-08
Cfixed37 n37 0 2.44656917885e-12
Dvar37 n37 vb DVAR
Rbleed37 n37 0 160000
Rser38 n37 ns38 0.0133191004764
Lser38 ns38 n38 7.64552868391e-08
Cfixed38 n38 0 2.44656917885e-12
Dvar38 n38 vb DVAR
Rbleed38 n38 0 160000
Rser39 n38 ns39 0.0133191004764
Lser39 ns39 n39 7.64552868391e-08
Cfixed39 n39 0 2.44656917885e-12
Dvar39 n39 vb DVAR
Rbleed39 n39 0 160000
Rser40 n39 ns40 0.0133191004764
Lser40 ns40 n40 7.64552868391e-08
Cfixed40 n40 0 2.44656917885e-12
Dvar40 n40 vb DVAR
Rbleed40 n40 0 160000
Rser41 n40 ns41 0.0133191004764
Lser41 ns41 n41 7.64552868391e-08
Cfixed41 n41 0 2.44656917885e-12
Dvar41 n41 vb DVAR
Rbleed41 n41 0 160000
Rser42 n41 ns42 0.0133191004764
Lser42 ns42 n42 7.64552868391e-08
Cfixed42 n42 0 2.44656917885e-12
Dvar42 n42 vb DVAR
Rbleed42 n42 0 160000
Rser43 n42 ns43 0.0133191004764
Lser43 ns43 n43 7.64552868391e-08
Cfixed43 n43 0 2.44656917885e-12
Dvar43 n43 vb DVAR
Rbleed43 n43 0 160000
Rser44 n43 ns44 0.0133191004764
Lser44 ns44 n44 7.64552868391e-08
Cfixed44 n44 0 2.44656917885e-12
Dvar44 n44 vb DVAR
Rbleed44 n44 0 160000
Rser45 n44 ns45 0.0133191004764
Lser45 ns45 n45 7.64552868391e-08
Cfixed45 n45 0 2.44656917885e-12
Dvar45 n45 vb DVAR
Rbleed45 n45 0 160000
Rser46 n45 ns46 0.0133191004764
Lser46 ns46 n46 7.64552868391e-08
Cfixed46 n46 0 2.44656917885e-12
Dvar46 n46 vb DVAR
Rbleed46 n46 0 160000
Rser47 n46 ns47 0.0133191004764
Lser47 ns47 n47 7.64552868391e-08
Cfixed47 n47 0 2.44656917885e-12
Dvar47 n47 vb DVAR
Rbleed47 n47 0 160000
Rser48 n47 ns48 0.0133191004764
Lser48 ns48 n48 7.64552868391e-08
Cfixed48 n48 0 2.44656917885e-12
Dvar48 n48 vb DVAR
Rbleed48 n48 0 160000
Rser49 n48 ns49 0.0133191004764
Lser49 ns49 n49 7.64552868391e-08
Cfixed49 n49 0 2.44656917885e-12
Dvar49 n49 vb DVAR
Rbleed49 n49 0 160000
Rser50 n49 ns50 0.0133191004764
Lser50 ns50 n50 7.64552868391e-08
Cfixed50 n50 0 2.44656917885e-12
Dvar50 n50 vb DVAR
Rbleed50 n50 0 160000
Rser51 n50 ns51 0.0133191004764
Lser51 ns51 n51 7.64552868391e-08
Cfixed51 n51 0 2.44656917885e-12
Dvar51 n51 vb DVAR
Rbleed51 n51 0 160000
Rser52 n51 ns52 0.0133191004764
Lser52 ns52 n52 7.64552868391e-08
Cfixed52 n52 0 2.44656917885e-12
Dvar52 n52 vb DVAR
Rbleed52 n52 0 160000
Rser53 n52 ns53 0.0133191004764
Lser53 ns53 n53 7.64552868391e-08
Cfixed53 n53 0 2.44656917885e-12
Dvar53 n53 vb DVAR
Rbleed53 n53 0 160000
Rser54 n53 ns54 0.0133191004764
Lser54 ns54 n54 7.64552868391e-08
Cfixed54 n54 0 2.44656917885e-12
Dvar54 n54 vb DVAR
Rbleed54 n54 0 160000
Rser55 n54 ns55 0.0133191004764
Lser55 ns55 n55 7.64552868391e-08
Cfixed55 n55 0 2.44656917885e-12
Dvar55 n55 vb DVAR
Rbleed55 n55 0 160000
Rser56 n55 ns56 0.0133191004764
Lser56 ns56 n56 7.64552868391e-08
Cfixed56 n56 0 2.44656917885e-12
Dvar56 n56 vb DVAR
Rbleed56 n56 0 160000
Rser57 n56 ns57 0.0133191004764
Lser57 ns57 n57 7.64552868391e-08
Cfixed57 n57 0 2.44656917885e-12
Dvar57 n57 vb DVAR
Rbleed57 n57 0 160000
Rser58 n57 ns58 0.0133191004764
Lser58 ns58 n58 7.64552868391e-08
Cfixed58 n58 0 2.44656917885e-12
Dvar58 n58 vb DVAR
Rbleed58 n58 0 160000
Rser59 n58 ns59 0.0133191004764
Lser59 ns59 n59 7.64552868391e-08
Cfixed59 n59 0 2.44656917885e-12
Dvar59 n59 vb DVAR
Rbleed59 n59 0 160000
Rser60 n59 ns60 0.0133191004764
Lser60 ns60 n60 7.64552868391e-08
Cfixed60 n60 0 2.44656917885e-12
Dvar60 n60 vb DVAR
Rbleed60 n60 0 160000
Rser61 n60 ns61 0.0133191004764
Lser61 ns61 n61 7.64552868391e-08
Cfixed61 n61 0 2.44656917885e-12
Dvar61 n61 vb DVAR
Rbleed61 n61 0 160000
Rser62 n61 ns62 0.0133191004764
Lser62 ns62 n62 7.64552868391e-08
Cfixed62 n62 0 2.44656917885e-12
Dvar62 n62 vb DVAR
Rbleed62 n62 0 160000
Rser63 n62 ns63 0.0133191004764
Lser63 ns63 n63 7.64552868391e-08
Cfixed63 n63 0 2.44656917885e-12
Dvar63 n63 vb DVAR
Rbleed63 n63 0 160000
Rser64 n63 ns64 0.0133191004764
Lser64 ns64 n64 7.64552868391e-08
Cbase64 n64 0 1.35920509936e-11
Rbleed64 n64 0 160000
Rser65 n64 ns65 0.0133191004764
Lser65 ns65 n65 7.64552868391e-08
Cbase65 n65 0 1.35920509936e-11
Rbleed65 n65 0 160000
Rser66 n65 ns66 0.0133191004764
Lser66 ns66 n66 7.64552868391e-08
Cbase66 n66 0 1.35920509936e-11
Rbleed66 n66 0 160000
Rser67 n66 ns67 0.0133191004764
Lser67 ns67 n67 7.64552868391e-08
Cbase67 n67 0 1.35920509936e-11
Rbleed67 n67 0 160000
Rser68 n67 ns68 0.0133191004764
Lser68 ns68 n68 7.64552868391e-08
Cbase68 n68 0 1.35920509936e-11
Rbleed68 n68 0 160000
Rser69 n68 ns69 0.0133191004764
Lser69 ns69 n69 7.64552868391e-08
Cbase69 n69 0 1.35920509936e-11
Rbleed69 n69 0 160000
Rser70 n69 ns70 0.0133191004764
Lser70 ns70 n70 7.64552868391e-08
Cbase70 n70 0 1.35920509936e-11
Rbleed70 n70 0 160000
Rser71 n70 ns71 0.0133191004764
Lser71 ns71 n71 7.64552868391e-08
Cbase71 n71 0 1.35920509936e-11
Rbleed71 n71 0 160000
Rser72 n71 ns72 0.0133191004764
Lser72 ns72 n72 7.64552868391e-08
Cbase72 n72 0 1.35920509936e-11
Rbleed72 n72 0 160000
Rser73 n72 ns73 0.0133191004764
Lser73 ns73 n73 7.64552868391e-08
Cbase73 n73 0 1.35920509936e-11
Rbleed73 n73 0 160000
Rser74 n73 ns74 0.0133191004764
Lser74 ns74 n74 7.64552868391e-08
Cbase74 n74 0 1.35920509936e-11
Rbleed74 n74 0 160000
Rser75 n74 ns75 0.0133191004764
Lser75 ns75 n75 7.64552868391e-08
Cbase75 n75 0 1.35920509936e-11
Rbleed75 n75 0 160000
Rser76 n75 ns76 0.0133191004764
Lser76 ns76 n76 7.64552868391e-08
Cbase76 n76 0 1.35920509936e-11
Rbleed76 n76 0 160000
Rser77 n76 ns77 0.0133191004764
Lser77 ns77 n77 7.64552868391e-08
Cbase77 n77 0 1.35920509936e-11
Rbleed77 n77 0 160000
Rser78 n77 ns78 0.0133191004764
Lser78 ns78 n78 7.64552868391e-08
Cbase78 n78 0 1.35920509936e-11
Rbleed78 n78 0 160000
Rser79 n78 ns79 0.0133191004764
Lser79 ns79 n79 7.64552868391e-08
Cbase79 n79 0 1.35920509936e-11
Rbleed79 n79 0 160000
Rser80 n79 ns80 0.0133191004764
Lser80 ns80 n80 7.64552868391e-08
Cbase80 n80 0 1.35920509936e-11
Rbleed80 n80 0 160000
Rser81 n80 ns81 0.0133191004764
Lser81 ns81 n81 7.64552868391e-08
Cbase81 n81 0 1.35920509936e-11
Rbleed81 n81 0 160000
Rser82 n81 ns82 0.0133191004764
Lser82 ns82 n82 7.64552868391e-08
Cbase82 n82 0 1.35920509936e-11
Rbleed82 n82 0 160000
Rser83 n82 ns83 0.0133191004764
Lser83 ns83 n83 7.64552868391e-08
Cbase83 n83 0 1.35920509936e-11
Rbleed83 n83 0 160000
Rser84 n83 ns84 0.0133191004764
Lser84 ns84 n84 7.64552868391e-08
Cbase84 n84 0 1.35920509936e-11
Rbleed84 n84 0 160000
Rser85 n84 ns85 0.0133191004764
Lser85 ns85 n85 7.64552868391e-08
Cbase85 n85 0 1.35920509936e-11
Rbleed85 n85 0 160000
Rser86 n85 ns86 0.0133191004764
Lser86 ns86 n86 7.64552868391e-08
Cbase86 n86 0 1.35920509936e-11
Rbleed86 n86 0 160000
Rser87 n86 ns87 0.0133191004764
Lser87 ns87 n87 7.64552868391e-08
Cbase87 n87 0 1.35920509936e-11
Rbleed87 n87 0 160000
Rser88 n87 ns88 0.0133191004764
Lser88 ns88 n88 7.64552868391e-08
Cbase88 n88 0 1.35920509936e-11
Rbleed88 n88 0 160000
Rser89 n88 ns89 0.0133191004764
Lser89 ns89 n89 7.64552868391e-08
Cbase89 n89 0 1.35920509936e-11
Rbleed89 n89 0 160000
Rser90 n89 ns90 0.0133191004764
Lser90 ns90 n90 7.64552868391e-08
Cbase90 n90 0 1.35920509936e-11
Rbleed90 n90 0 160000
Rser91 n90 ns91 0.0133191004764
Lser91 ns91 n91 7.64552868391e-08
Cbase91 n91 0 1.35920509936e-11
Rbleed91 n91 0 160000
Rser92 n91 ns92 0.0133191004764
Lser92 ns92 n92 7.64552868391e-08
Cbase92 n92 0 1.35920509936e-11
Rbleed92 n92 0 160000
Rser93 n92 ns93 0.0133191004764
Lser93 ns93 n93 7.64552868391e-08
Cbase93 n93 0 1.35920509936e-11
Rbleed93 n93 0 160000
Rser94 n93 ns94 0.0133191004764
Lser94 ns94 n94 7.64552868391e-08
Cbase94 n94 0 1.35920509936e-11
Rbleed94 n94 0 160000
Rser95 n94 ns95 0.0133191004764
Lser95 ns95 n95 7.64552868391e-08
Cbase95 n95 0 1.35920509936e-11
Rbleed95 n95 0 160000
Rser96 n95 ns96 0.0133191004764
Lser96 ns96 n96 7.64552868391e-08
Cbase96 n96 0 1.35920509936e-11
Rbleed96 n96 0 160000
Rser97 n96 ns97 0.0133191004764
Lser97 ns97 n97 7.64552868391e-08
Cbase97 n97 0 1.35920509936e-11
Rbleed97 n97 0 160000
Rser98 n97 ns98 0.0133191004764
Lser98 ns98 n98 7.64552868391e-08
Cbase98 n98 0 1.35920509936e-11
Rbleed98 n98 0 160000
Rser99 n98 ns99 0.0133191004764
Lser99 ns99 n99 7.64552868391e-08
Cbase99 n99 0 1.35920509936e-11
Rbleed99 n99 0 160000
Rser100 n99 ns100 0.0133191004764
Lser100 ns100 n100 7.64552868391e-08
Cbase100 n100 0 1.35920509936e-11
Rbleed100 n100 0 160000
Rser101 n100 ns101 0.0133191004764
Lser101 ns101 n101 7.64552868391e-08
Cbase101 n101 0 1.35920509936e-11
Rbleed101 n101 0 160000
Rser102 n101 ns102 0.0133191004764
Lser102 ns102 n102 7.64552868391e-08
Cbase102 n102 0 1.35920509936e-11
Rbleed102 n102 0 160000
Rser103 n102 ns103 0.0133191004764
Lser103 ns103 n103 7.64552868391e-08
Cbase103 n103 0 1.35920509936e-11
Rbleed103 n103 0 160000
Rser104 n103 ns104 0.0133191004764
Lser104 ns104 n104 7.64552868391e-08
Cbase104 n104 0 1.35920509936e-11
Rbleed104 n104 0 160000
Rser105 n104 ns105 0.0133191004764
Lser105 ns105 n105 7.64552868391e-08
Cbase105 n105 0 1.35920509936e-11
Rbleed105 n105 0 160000
Rser106 n105 ns106 0.0133191004764
Lser106 ns106 n106 7.64552868391e-08
Cbase106 n106 0 1.35920509936e-11
Rbleed106 n106 0 160000
Rser107 n106 ns107 0.0133191004764
Lser107 ns107 n107 7.64552868391e-08
Cbase107 n107 0 1.35920509936e-11
Rbleed107 n107 0 160000
Rser108 n107 ns108 0.0133191004764
Lser108 ns108 n108 7.64552868391e-08
Cbase108 n108 0 1.35920509936e-11
Rbleed108 n108 0 160000
Rser109 n108 ns109 0.0133191004764
Lser109 ns109 n109 7.64552868391e-08
Cbase109 n109 0 1.35920509936e-11
Rbleed109 n109 0 160000
Rser110 n109 ns110 0.0133191004764
Lser110 ns110 n110 7.64552868391e-08
Cbase110 n110 0 1.35920509936e-11
Rbleed110 n110 0 160000
Rser111 n110 ns111 0.0133191004764
Lser111 ns111 n111 7.64552868391e-08
Cbase111 n111 0 1.35920509936e-11
Rbleed111 n111 0 160000
Rser112 n111 ns112 0.0133191004764
Lser112 ns112 n112 7.64552868391e-08
Cbase112 n112 0 1.35920509936e-11
Rbleed112 n112 0 160000
Bmag49 n49 0 I={(1.10856941071)*kmag*V(n49)*V(n49)*V(n49)/(1+(V(n49)/7.5)**2) + gcore*V(n49)}
Bmag53 n53 0 I={(1.11165627002)*kmag*V(n53)*V(n53)*V(n53)/(1+(V(n53)/7.5)**2) + gcore*V(n53)}
Bmag57 n57 0 I={(1.11460072575)*kmag*V(n57)*V(n57)*V(n57)/(1+(V(n57)/7.5)**2) + gcore*V(n57)}
Bmag61 n61 0 I={(1.11739902263)*kmag*V(n61)*V(n61)*V(n61)/(1+(V(n61)/7.5)**2) + gcore*V(n61)}
Bmag65 n65 0 I={(1.12004759177)*kmag*V(n65)*V(n65)*V(n65)/(1+(V(n65)/7.5)**2) + gcore*V(n65)}
Bmag69 n69 0 I={(1.12254305526)*kmag*V(n69)*V(n69)*V(n69)/(1+(V(n69)/7.5)**2) + gcore*V(n69)}
Bmag73 n73 0 I={(1.12488223045)*kmag*V(n73)*V(n73)*V(n73)/(1+(V(n73)/7.5)**2) + gcore*V(n73)}
Bmag77 n77 0 I={(1.12706213401)*kmag*V(n77)*V(n77)*V(n77)/(1+(V(n77)/7.5)**2) + gcore*V(n77)}
Bmag81 n81 0 I={(1.12907998574)*kmag*V(n81)*V(n81)*V(n81)/(1+(V(n81)/7.5)**2) + gcore*V(n81)}
Bmag85 n85 0 I={(1.13093321213)*kmag*V(n85)*V(n85)*V(n85)/(1+(V(n85)/7.5)**2) + gcore*V(n85)}
Bmag89 n89 0 I={(1.13261944963)*kmag*V(n89)*V(n89)*V(n89)/(1+(V(n89)/7.5)**2) + gcore*V(n89)}
Bmag93 n93 0 I={(1.13413654765)*kmag*V(n93)*V(n93)*V(n93)/(1+(V(n93)/7.5)**2) + gcore*V(n93)}
Bmag97 n97 0 I={(1.13548257131)*kmag*V(n97)*V(n97)*V(n97)/(1+(V(n97)/7.5)**2) + gcore*V(n97)}
Bmag101 n101 0 I={(1.13665580394)*kmag*V(n101)*V(n101)*V(n101)/(1+(V(n101)/7.5)**2) + gcore*V(n101)}
Bmag105 n105 0 I={(1.13765474923)*kmag*V(n105)*V(n105)*V(n105)/(1+(V(n105)/7.5)**2) + gcore*V(n105)}
Bmag109 n109 0 I={(1.13847813314)*kmag*V(n109)*V(n109)*V(n109)/(1+(V(n109)/7.5)**2) + gcore*V(n109)}
Rlock50 n112 lk50r 21.5657104461
Llock50 lk50r lk50l 1.23562419076e-06
Clock50 lk50l 0 8.2e-12
Rlock100 n112 lk100r 14.2185399976
Llock100 lk100r lk100l 4.06112827865e-07
Clock100 lk100l 0 6.2e-12
Rext1 n112 ext1r 12.604784608
Lext1 ext1r ext1l 2.41943370087e-07
Cext1 ext1l v150s1 4.7e-12
Rload150_1 v150s1 0 170
Rext2 v150s1 ext2r 11.3189516954
Lext2 ext2r ext2l 2.78095827686e-07
Cext2 ext2l v150 4.089e-12
Rload150_2 v150 0 229.5
.control
set filetype=ascii
set wr_singlescale
set wr_vecnames
tran 5e-10 5.5e-07 0 2e-10
wrdata p025_h024_cascaded_112c_75ohm_tran.csv time v(n0) v(n56) v(v150) i(Vsrc) i(Vbias)
.endc
.end

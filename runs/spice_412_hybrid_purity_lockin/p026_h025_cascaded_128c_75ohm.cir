* p026_h025_cascaded_128c_75ohm
* Hybrid purity lock-in: source-only 50 MHz, passive 150 MHz extraction.
* role=discovery; source_only=True; no direct 100/150 MHz discovery drive.
* extraction=cascaded; stages=2; q_label=medium
.option method=gear maxord=2 reltol=2e-4 abstol=1e-12 vntol=1e-6 chgtol=1e-16 itl4=320
.model DVAR D(Is=1e-15 Rs=0.3 Cjo=4.87765785963e-11 Vj=0.62 M=0.6 Bv=18 Ibv=1e-06)
.param kmag=1.01475e-06
.param gcore=1.35e-07
Vbias vb 0 DC 3.4
Vsrc src 0 SIN(0 2.25 50000000)
Rsrc src n0 75
Rrawload n128 0 300
Cbase0 n0 0 1.43536745407e-11
Rbleed0 n0 0 160000
Rser1 n0 ns1 0.0116542129168
Lser1 ns1 n1 8.07394192913e-08
Cfixed1 n1 0 2.58366141732e-12
Dvar1a n1 vst1 DVAR
Dvar1b vst1 vb DVAR
Rstack1 vst1 vb 2000000
Rbleed1 n1 0 160000
Rser2 n1 ns2 0.0116542129168
Lser2 ns2 n2 8.07394192913e-08
Cfixed2 n2 0 2.58366141732e-12
Dvar2a n2 vst2 DVAR
Dvar2b vst2 vb DVAR
Rstack2 vst2 vb 2000000
Rbleed2 n2 0 160000
Rser3 n2 ns3 0.0116542129168
Lser3 ns3 n3 8.07394192913e-08
Cfixed3 n3 0 2.58366141732e-12
Dvar3a n3 vst3 DVAR
Dvar3b vst3 vb DVAR
Rstack3 vst3 vb 2000000
Rbleed3 n3 0 160000
Rser4 n3 ns4 0.0116542129168
Lser4 ns4 n4 8.07394192913e-08
Cfixed4 n4 0 2.58366141732e-12
Dvar4a n4 vst4 DVAR
Dvar4b vst4 vb DVAR
Rstack4 vst4 vb 2000000
Rbleed4 n4 0 160000
Rser5 n4 ns5 0.0116542129168
Lser5 ns5 n5 8.07394192913e-08
Cfixed5 n5 0 2.58366141732e-12
Dvar5a n5 vst5 DVAR
Dvar5b vst5 vb DVAR
Rstack5 vst5 vb 2000000
Rbleed5 n5 0 160000
Rser6 n5 ns6 0.0116542129168
Lser6 ns6 n6 8.07394192913e-08
Cfixed6 n6 0 2.58366141732e-12
Dvar6a n6 vst6 DVAR
Dvar6b vst6 vb DVAR
Rstack6 vst6 vb 2000000
Rbleed6 n6 0 160000
Rser7 n6 ns7 0.0116542129168
Lser7 ns7 n7 8.07394192913e-08
Cfixed7 n7 0 2.58366141732e-12
Dvar7a n7 vst7 DVAR
Dvar7b vst7 vb DVAR
Rstack7 vst7 vb 2000000
Rbleed7 n7 0 160000
Rser8 n7 ns8 0.0116542129168
Lser8 ns8 n8 8.07394192913e-08
Cfixed8 n8 0 2.58366141732e-12
Dvar8a n8 vst8 DVAR
Dvar8b vst8 vb DVAR
Rstack8 vst8 vb 2000000
Rbleed8 n8 0 160000
Rser9 n8 ns9 0.0116542129168
Lser9 ns9 n9 8.07394192913e-08
Cfixed9 n9 0 2.58366141732e-12
Dvar9a n9 vst9 DVAR
Dvar9b vst9 vb DVAR
Rstack9 vst9 vb 2000000
Rbleed9 n9 0 160000
Rser10 n9 ns10 0.0116542129168
Lser10 ns10 n10 8.07394192913e-08
Cfixed10 n10 0 2.58366141732e-12
Dvar10a n10 vst10 DVAR
Dvar10b vst10 vb DVAR
Rstack10 vst10 vb 2000000
Rbleed10 n10 0 160000
Rser11 n10 ns11 0.0116542129168
Lser11 ns11 n11 8.07394192913e-08
Cfixed11 n11 0 2.58366141732e-12
Dvar11a n11 vst11 DVAR
Dvar11b vst11 vb DVAR
Rstack11 vst11 vb 2000000
Rbleed11 n11 0 160000
Rser12 n11 ns12 0.0116542129168
Lser12 ns12 n12 8.07394192913e-08
Cfixed12 n12 0 2.58366141732e-12
Dvar12a n12 vst12 DVAR
Dvar12b vst12 vb DVAR
Rstack12 vst12 vb 2000000
Rbleed12 n12 0 160000
Rser13 n12 ns13 0.0116542129168
Lser13 ns13 n13 8.07394192913e-08
Cfixed13 n13 0 2.58366141732e-12
Dvar13a n13 vst13 DVAR
Dvar13b vst13 vb DVAR
Rstack13 vst13 vb 2000000
Rbleed13 n13 0 160000
Rser14 n13 ns14 0.0116542129168
Lser14 ns14 n14 8.07394192913e-08
Cfixed14 n14 0 2.58366141732e-12
Dvar14a n14 vst14 DVAR
Dvar14b vst14 vb DVAR
Rstack14 vst14 vb 2000000
Rbleed14 n14 0 160000
Rser15 n14 ns15 0.0116542129168
Lser15 ns15 n15 8.07394192913e-08
Cfixed15 n15 0 2.58366141732e-12
Dvar15a n15 vst15 DVAR
Dvar15b vst15 vb DVAR
Rstack15 vst15 vb 2000000
Rbleed15 n15 0 160000
Rser16 n15 ns16 0.0116542129168
Lser16 ns16 n16 8.07394192913e-08
Cfixed16 n16 0 2.58366141732e-12
Dvar16a n16 vst16 DVAR
Dvar16b vst16 vb DVAR
Rstack16 vst16 vb 2000000
Rbleed16 n16 0 160000
Rser17 n16 ns17 0.0116542129168
Lser17 ns17 n17 8.07394192913e-08
Cfixed17 n17 0 2.58366141732e-12
Dvar17a n17 vst17 DVAR
Dvar17b vst17 vb DVAR
Rstack17 vst17 vb 2000000
Rbleed17 n17 0 160000
Rser18 n17 ns18 0.0116542129168
Lser18 ns18 n18 8.07394192913e-08
Cfixed18 n18 0 2.58366141732e-12
Dvar18a n18 vst18 DVAR
Dvar18b vst18 vb DVAR
Rstack18 vst18 vb 2000000
Rbleed18 n18 0 160000
Rser19 n18 ns19 0.0116542129168
Lser19 ns19 n19 8.07394192913e-08
Cfixed19 n19 0 2.58366141732e-12
Dvar19a n19 vst19 DVAR
Dvar19b vst19 vb DVAR
Rstack19 vst19 vb 2000000
Rbleed19 n19 0 160000
Rser20 n19 ns20 0.0116542129168
Lser20 ns20 n20 8.07394192913e-08
Cfixed20 n20 0 2.58366141732e-12
Dvar20a n20 vst20 DVAR
Dvar20b vst20 vb DVAR
Rstack20 vst20 vb 2000000
Rbleed20 n20 0 160000
Rser21 n20 ns21 0.0116542129168
Lser21 ns21 n21 8.07394192913e-08
Cfixed21 n21 0 2.58366141732e-12
Dvar21a n21 vst21 DVAR
Dvar21b vst21 vb DVAR
Rstack21 vst21 vb 2000000
Rbleed21 n21 0 160000
Rser22 n21 ns22 0.0116542129168
Lser22 ns22 n22 8.07394192913e-08
Cfixed22 n22 0 2.58366141732e-12
Dvar22a n22 vst22 DVAR
Dvar22b vst22 vb DVAR
Rstack22 vst22 vb 2000000
Rbleed22 n22 0 160000
Rser23 n22 ns23 0.0116542129168
Lser23 ns23 n23 8.07394192913e-08
Cfixed23 n23 0 2.58366141732e-12
Dvar23a n23 vst23 DVAR
Dvar23b vst23 vb DVAR
Rstack23 vst23 vb 2000000
Rbleed23 n23 0 160000
Rser24 n23 ns24 0.0116542129168
Lser24 ns24 n24 8.07394192913e-08
Cfixed24 n24 0 2.58366141732e-12
Dvar24a n24 vst24 DVAR
Dvar24b vst24 vb DVAR
Rstack24 vst24 vb 2000000
Rbleed24 n24 0 160000
Rser25 n24 ns25 0.0116542129168
Lser25 ns25 n25 8.07394192913e-08
Cfixed25 n25 0 2.58366141732e-12
Dvar25a n25 vst25 DVAR
Dvar25b vst25 vb DVAR
Rstack25 vst25 vb 2000000
Rbleed25 n25 0 160000
Rser26 n25 ns26 0.0116542129168
Lser26 ns26 n26 8.07394192913e-08
Cfixed26 n26 0 2.58366141732e-12
Dvar26a n26 vst26 DVAR
Dvar26b vst26 vb DVAR
Rstack26 vst26 vb 2000000
Rbleed26 n26 0 160000
Rser27 n26 ns27 0.0116542129168
Lser27 ns27 n27 8.07394192913e-08
Cfixed27 n27 0 2.58366141732e-12
Dvar27a n27 vst27 DVAR
Dvar27b vst27 vb DVAR
Rstack27 vst27 vb 2000000
Rbleed27 n27 0 160000
Rser28 n27 ns28 0.0116542129168
Lser28 ns28 n28 8.07394192913e-08
Cfixed28 n28 0 2.58366141732e-12
Dvar28a n28 vst28 DVAR
Dvar28b vst28 vb DVAR
Rstack28 vst28 vb 2000000
Rbleed28 n28 0 160000
Rser29 n28 ns29 0.0116542129168
Lser29 ns29 n29 8.07394192913e-08
Cfixed29 n29 0 2.58366141732e-12
Dvar29a n29 vst29 DVAR
Dvar29b vst29 vb DVAR
Rstack29 vst29 vb 2000000
Rbleed29 n29 0 160000
Rser30 n29 ns30 0.0116542129168
Lser30 ns30 n30 8.07394192913e-08
Cfixed30 n30 0 2.58366141732e-12
Dvar30a n30 vst30 DVAR
Dvar30b vst30 vb DVAR
Rstack30 vst30 vb 2000000
Rbleed30 n30 0 160000
Rser31 n30 ns31 0.0116542129168
Lser31 ns31 n31 8.07394192913e-08
Cfixed31 n31 0 2.58366141732e-12
Dvar31a n31 vst31 DVAR
Dvar31b vst31 vb DVAR
Rstack31 vst31 vb 2000000
Rbleed31 n31 0 160000
Rser32 n31 ns32 0.0116542129168
Lser32 ns32 n32 8.07394192913e-08
Cfixed32 n32 0 2.58366141732e-12
Dvar32a n32 vst32 DVAR
Dvar32b vst32 vb DVAR
Rstack32 vst32 vb 2000000
Rbleed32 n32 0 160000
Rser33 n32 ns33 0.0116542129168
Lser33 ns33 n33 8.07394192913e-08
Cfixed33 n33 0 2.58366141732e-12
Dvar33a n33 vst33 DVAR
Dvar33b vst33 vb DVAR
Rstack33 vst33 vb 2000000
Rbleed33 n33 0 160000
Rser34 n33 ns34 0.0116542129168
Lser34 ns34 n34 8.07394192913e-08
Cfixed34 n34 0 2.58366141732e-12
Dvar34a n34 vst34 DVAR
Dvar34b vst34 vb DVAR
Rstack34 vst34 vb 2000000
Rbleed34 n34 0 160000
Rser35 n34 ns35 0.0116542129168
Lser35 ns35 n35 8.07394192913e-08
Cfixed35 n35 0 2.58366141732e-12
Dvar35a n35 vst35 DVAR
Dvar35b vst35 vb DVAR
Rstack35 vst35 vb 2000000
Rbleed35 n35 0 160000
Rser36 n35 ns36 0.0116542129168
Lser36 ns36 n36 8.07394192913e-08
Cfixed36 n36 0 2.58366141732e-12
Dvar36a n36 vst36 DVAR
Dvar36b vst36 vb DVAR
Rstack36 vst36 vb 2000000
Rbleed36 n36 0 160000
Rser37 n36 ns37 0.0116542129168
Lser37 ns37 n37 8.07394192913e-08
Cfixed37 n37 0 2.58366141732e-12
Dvar37a n37 vst37 DVAR
Dvar37b vst37 vb DVAR
Rstack37 vst37 vb 2000000
Rbleed37 n37 0 160000
Rser38 n37 ns38 0.0116542129168
Lser38 ns38 n38 8.07394192913e-08
Cfixed38 n38 0 2.58366141732e-12
Dvar38a n38 vst38 DVAR
Dvar38b vst38 vb DVAR
Rstack38 vst38 vb 2000000
Rbleed38 n38 0 160000
Rser39 n38 ns39 0.0116542129168
Lser39 ns39 n39 8.07394192913e-08
Cfixed39 n39 0 2.58366141732e-12
Dvar39a n39 vst39 DVAR
Dvar39b vst39 vb DVAR
Rstack39 vst39 vb 2000000
Rbleed39 n39 0 160000
Rser40 n39 ns40 0.0116542129168
Lser40 ns40 n40 8.07394192913e-08
Cfixed40 n40 0 2.58366141732e-12
Dvar40a n40 vst40 DVAR
Dvar40b vst40 vb DVAR
Rstack40 vst40 vb 2000000
Rbleed40 n40 0 160000
Rser41 n40 ns41 0.0116542129168
Lser41 ns41 n41 8.07394192913e-08
Cfixed41 n41 0 2.58366141732e-12
Dvar41a n41 vst41 DVAR
Dvar41b vst41 vb DVAR
Rstack41 vst41 vb 2000000
Rbleed41 n41 0 160000
Rser42 n41 ns42 0.0116542129168
Lser42 ns42 n42 8.07394192913e-08
Cfixed42 n42 0 2.58366141732e-12
Dvar42a n42 vst42 DVAR
Dvar42b vst42 vb DVAR
Rstack42 vst42 vb 2000000
Rbleed42 n42 0 160000
Rser43 n42 ns43 0.0116542129168
Lser43 ns43 n43 8.07394192913e-08
Cfixed43 n43 0 2.58366141732e-12
Dvar43a n43 vst43 DVAR
Dvar43b vst43 vb DVAR
Rstack43 vst43 vb 2000000
Rbleed43 n43 0 160000
Rser44 n43 ns44 0.0116542129168
Lser44 ns44 n44 8.07394192913e-08
Cfixed44 n44 0 2.58366141732e-12
Dvar44a n44 vst44 DVAR
Dvar44b vst44 vb DVAR
Rstack44 vst44 vb 2000000
Rbleed44 n44 0 160000
Rser45 n44 ns45 0.0116542129168
Lser45 ns45 n45 8.07394192913e-08
Cfixed45 n45 0 2.58366141732e-12
Dvar45a n45 vst45 DVAR
Dvar45b vst45 vb DVAR
Rstack45 vst45 vb 2000000
Rbleed45 n45 0 160000
Rser46 n45 ns46 0.0116542129168
Lser46 ns46 n46 8.07394192913e-08
Cfixed46 n46 0 2.58366141732e-12
Dvar46a n46 vst46 DVAR
Dvar46b vst46 vb DVAR
Rstack46 vst46 vb 2000000
Rbleed46 n46 0 160000
Rser47 n46 ns47 0.0116542129168
Lser47 ns47 n47 8.07394192913e-08
Cfixed47 n47 0 2.58366141732e-12
Dvar47a n47 vst47 DVAR
Dvar47b vst47 vb DVAR
Rstack47 vst47 vb 2000000
Rbleed47 n47 0 160000
Rser48 n47 ns48 0.0116542129168
Lser48 ns48 n48 8.07394192913e-08
Cfixed48 n48 0 2.58366141732e-12
Dvar48a n48 vst48 DVAR
Dvar48b vst48 vb DVAR
Rstack48 vst48 vb 2000000
Rbleed48 n48 0 160000
Rser49 n48 ns49 0.0116542129168
Lser49 ns49 n49 8.07394192913e-08
Cfixed49 n49 0 2.58366141732e-12
Dvar49a n49 vst49 DVAR
Dvar49b vst49 vb DVAR
Rstack49 vst49 vb 2000000
Rbleed49 n49 0 160000
Rser50 n49 ns50 0.0116542129168
Lser50 ns50 n50 8.07394192913e-08
Cfixed50 n50 0 2.58366141732e-12
Dvar50a n50 vst50 DVAR
Dvar50b vst50 vb DVAR
Rstack50 vst50 vb 2000000
Rbleed50 n50 0 160000
Rser51 n50 ns51 0.0116542129168
Lser51 ns51 n51 8.07394192913e-08
Cfixed51 n51 0 2.58366141732e-12
Dvar51a n51 vst51 DVAR
Dvar51b vst51 vb DVAR
Rstack51 vst51 vb 2000000
Rbleed51 n51 0 160000
Rser52 n51 ns52 0.0116542129168
Lser52 ns52 n52 8.07394192913e-08
Cfixed52 n52 0 2.58366141732e-12
Dvar52a n52 vst52 DVAR
Dvar52b vst52 vb DVAR
Rstack52 vst52 vb 2000000
Rbleed52 n52 0 160000
Rser53 n52 ns53 0.0116542129168
Lser53 ns53 n53 8.07394192913e-08
Cfixed53 n53 0 2.58366141732e-12
Dvar53a n53 vst53 DVAR
Dvar53b vst53 vb DVAR
Rstack53 vst53 vb 2000000
Rbleed53 n53 0 160000
Rser54 n53 ns54 0.0116542129168
Lser54 ns54 n54 8.07394192913e-08
Cfixed54 n54 0 2.58366141732e-12
Dvar54a n54 vst54 DVAR
Dvar54b vst54 vb DVAR
Rstack54 vst54 vb 2000000
Rbleed54 n54 0 160000
Rser55 n54 ns55 0.0116542129168
Lser55 ns55 n55 8.07394192913e-08
Cfixed55 n55 0 2.58366141732e-12
Dvar55a n55 vst55 DVAR
Dvar55b vst55 vb DVAR
Rstack55 vst55 vb 2000000
Rbleed55 n55 0 160000
Rser56 n55 ns56 0.0116542129168
Lser56 ns56 n56 8.07394192913e-08
Cfixed56 n56 0 2.58366141732e-12
Dvar56a n56 vst56 DVAR
Dvar56b vst56 vb DVAR
Rstack56 vst56 vb 2000000
Rbleed56 n56 0 160000
Rser57 n56 ns57 0.0116542129168
Lser57 ns57 n57 8.07394192913e-08
Cfixed57 n57 0 2.58366141732e-12
Dvar57a n57 vst57 DVAR
Dvar57b vst57 vb DVAR
Rstack57 vst57 vb 2000000
Rbleed57 n57 0 160000
Rser58 n57 ns58 0.0116542129168
Lser58 ns58 n58 8.07394192913e-08
Cfixed58 n58 0 2.58366141732e-12
Dvar58a n58 vst58 DVAR
Dvar58b vst58 vb DVAR
Rstack58 vst58 vb 2000000
Rbleed58 n58 0 160000
Rser59 n58 ns59 0.0116542129168
Lser59 ns59 n59 8.07394192913e-08
Cfixed59 n59 0 2.58366141732e-12
Dvar59a n59 vst59 DVAR
Dvar59b vst59 vb DVAR
Rstack59 vst59 vb 2000000
Rbleed59 n59 0 160000
Rser60 n59 ns60 0.0116542129168
Lser60 ns60 n60 8.07394192913e-08
Cfixed60 n60 0 2.58366141732e-12
Dvar60a n60 vst60 DVAR
Dvar60b vst60 vb DVAR
Rstack60 vst60 vb 2000000
Rbleed60 n60 0 160000
Rser61 n60 ns61 0.0116542129168
Lser61 ns61 n61 8.07394192913e-08
Cfixed61 n61 0 2.58366141732e-12
Dvar61a n61 vst61 DVAR
Dvar61b vst61 vb DVAR
Rstack61 vst61 vb 2000000
Rbleed61 n61 0 160000
Rser62 n61 ns62 0.0116542129168
Lser62 ns62 n62 8.07394192913e-08
Cfixed62 n62 0 2.58366141732e-12
Dvar62a n62 vst62 DVAR
Dvar62b vst62 vb DVAR
Rstack62 vst62 vb 2000000
Rbleed62 n62 0 160000
Rser63 n62 ns63 0.0116542129168
Lser63 ns63 n63 8.07394192913e-08
Cfixed63 n63 0 2.58366141732e-12
Dvar63a n63 vst63 DVAR
Dvar63b vst63 vb DVAR
Rstack63 vst63 vb 2000000
Rbleed63 n63 0 160000
Rser64 n63 ns64 0.0116542129168
Lser64 ns64 n64 8.07394192913e-08
Cfixed64 n64 0 2.58366141732e-12
Dvar64a n64 vst64 DVAR
Dvar64b vst64 vb DVAR
Rstack64 vst64 vb 2000000
Rbleed64 n64 0 160000
Rser65 n64 ns65 0.0116542129168
Lser65 ns65 n65 8.07394192913e-08
Cfixed65 n65 0 2.58366141732e-12
Dvar65a n65 vst65 DVAR
Dvar65b vst65 vb DVAR
Rstack65 vst65 vb 2000000
Rbleed65 n65 0 160000
Rser66 n65 ns66 0.0116542129168
Lser66 ns66 n66 8.07394192913e-08
Cfixed66 n66 0 2.58366141732e-12
Dvar66a n66 vst66 DVAR
Dvar66b vst66 vb DVAR
Rstack66 vst66 vb 2000000
Rbleed66 n66 0 160000
Rser67 n66 ns67 0.0116542129168
Lser67 ns67 n67 8.07394192913e-08
Cfixed67 n67 0 2.58366141732e-12
Dvar67a n67 vst67 DVAR
Dvar67b vst67 vb DVAR
Rstack67 vst67 vb 2000000
Rbleed67 n67 0 160000
Rser68 n67 ns68 0.0116542129168
Lser68 ns68 n68 8.07394192913e-08
Cfixed68 n68 0 2.58366141732e-12
Dvar68a n68 vst68 DVAR
Dvar68b vst68 vb DVAR
Rstack68 vst68 vb 2000000
Rbleed68 n68 0 160000
Rser69 n68 ns69 0.0116542129168
Lser69 ns69 n69 8.07394192913e-08
Cfixed69 n69 0 2.58366141732e-12
Dvar69a n69 vst69 DVAR
Dvar69b vst69 vb DVAR
Rstack69 vst69 vb 2000000
Rbleed69 n69 0 160000
Rser70 n69 ns70 0.0116542129168
Lser70 ns70 n70 8.07394192913e-08
Cfixed70 n70 0 2.58366141732e-12
Dvar70a n70 vst70 DVAR
Dvar70b vst70 vb DVAR
Rstack70 vst70 vb 2000000
Rbleed70 n70 0 160000
Rser71 n70 ns71 0.0116542129168
Lser71 ns71 n71 8.07394192913e-08
Cfixed71 n71 0 2.58366141732e-12
Dvar71a n71 vst71 DVAR
Dvar71b vst71 vb DVAR
Rstack71 vst71 vb 2000000
Rbleed71 n71 0 160000
Rser72 n71 ns72 0.0116542129168
Lser72 ns72 n72 8.07394192913e-08
Cfixed72 n72 0 2.58366141732e-12
Dvar72a n72 vst72 DVAR
Dvar72b vst72 vb DVAR
Rstack72 vst72 vb 2000000
Rbleed72 n72 0 160000
Rser73 n72 ns73 0.0116542129168
Lser73 ns73 n73 8.07394192913e-08
Cbase73 n73 0 1.43536745407e-11
Rbleed73 n73 0 160000
Rser74 n73 ns74 0.0116542129168
Lser74 ns74 n74 8.07394192913e-08
Cbase74 n74 0 1.43536745407e-11
Rbleed74 n74 0 160000
Rser75 n74 ns75 0.0116542129168
Lser75 ns75 n75 8.07394192913e-08
Cbase75 n75 0 1.43536745407e-11
Rbleed75 n75 0 160000
Rser76 n75 ns76 0.0116542129168
Lser76 ns76 n76 8.07394192913e-08
Cbase76 n76 0 1.43536745407e-11
Rbleed76 n76 0 160000
Rser77 n76 ns77 0.0116542129168
Lser77 ns77 n77 8.07394192913e-08
Cbase77 n77 0 1.43536745407e-11
Rbleed77 n77 0 160000
Rser78 n77 ns78 0.0116542129168
Lser78 ns78 n78 8.07394192913e-08
Cbase78 n78 0 1.43536745407e-11
Rbleed78 n78 0 160000
Rser79 n78 ns79 0.0116542129168
Lser79 ns79 n79 8.07394192913e-08
Cbase79 n79 0 1.43536745407e-11
Rbleed79 n79 0 160000
Rser80 n79 ns80 0.0116542129168
Lser80 ns80 n80 8.07394192913e-08
Cbase80 n80 0 1.43536745407e-11
Rbleed80 n80 0 160000
Rser81 n80 ns81 0.0116542129168
Lser81 ns81 n81 8.07394192913e-08
Cbase81 n81 0 1.43536745407e-11
Rbleed81 n81 0 160000
Rser82 n81 ns82 0.0116542129168
Lser82 ns82 n82 8.07394192913e-08
Cbase82 n82 0 1.43536745407e-11
Rbleed82 n82 0 160000
Rser83 n82 ns83 0.0116542129168
Lser83 ns83 n83 8.07394192913e-08
Cbase83 n83 0 1.43536745407e-11
Rbleed83 n83 0 160000
Rser84 n83 ns84 0.0116542129168
Lser84 ns84 n84 8.07394192913e-08
Cbase84 n84 0 1.43536745407e-11
Rbleed84 n84 0 160000
Rser85 n84 ns85 0.0116542129168
Lser85 ns85 n85 8.07394192913e-08
Cbase85 n85 0 1.43536745407e-11
Rbleed85 n85 0 160000
Rser86 n85 ns86 0.0116542129168
Lser86 ns86 n86 8.07394192913e-08
Cbase86 n86 0 1.43536745407e-11
Rbleed86 n86 0 160000
Rser87 n86 ns87 0.0116542129168
Lser87 ns87 n87 8.07394192913e-08
Cbase87 n87 0 1.43536745407e-11
Rbleed87 n87 0 160000
Rser88 n87 ns88 0.0116542129168
Lser88 ns88 n88 8.07394192913e-08
Cbase88 n88 0 1.43536745407e-11
Rbleed88 n88 0 160000
Rser89 n88 ns89 0.0116542129168
Lser89 ns89 n89 8.07394192913e-08
Cbase89 n89 0 1.43536745407e-11
Rbleed89 n89 0 160000
Rser90 n89 ns90 0.0116542129168
Lser90 ns90 n90 8.07394192913e-08
Cbase90 n90 0 1.43536745407e-11
Rbleed90 n90 0 160000
Rser91 n90 ns91 0.0116542129168
Lser91 ns91 n91 8.07394192913e-08
Cbase91 n91 0 1.43536745407e-11
Rbleed91 n91 0 160000
Rser92 n91 ns92 0.0116542129168
Lser92 ns92 n92 8.07394192913e-08
Cbase92 n92 0 1.43536745407e-11
Rbleed92 n92 0 160000
Rser93 n92 ns93 0.0116542129168
Lser93 ns93 n93 8.07394192913e-08
Cbase93 n93 0 1.43536745407e-11
Rbleed93 n93 0 160000
Rser94 n93 ns94 0.0116542129168
Lser94 ns94 n94 8.07394192913e-08
Cbase94 n94 0 1.43536745407e-11
Rbleed94 n94 0 160000
Rser95 n94 ns95 0.0116542129168
Lser95 ns95 n95 8.07394192913e-08
Cbase95 n95 0 1.43536745407e-11
Rbleed95 n95 0 160000
Rser96 n95 ns96 0.0116542129168
Lser96 ns96 n96 8.07394192913e-08
Cbase96 n96 0 1.43536745407e-11
Rbleed96 n96 0 160000
Rser97 n96 ns97 0.0116542129168
Lser97 ns97 n97 8.07394192913e-08
Cbase97 n97 0 1.43536745407e-11
Rbleed97 n97 0 160000
Rser98 n97 ns98 0.0116542129168
Lser98 ns98 n98 8.07394192913e-08
Cbase98 n98 0 1.43536745407e-11
Rbleed98 n98 0 160000
Rser99 n98 ns99 0.0116542129168
Lser99 ns99 n99 8.07394192913e-08
Cbase99 n99 0 1.43536745407e-11
Rbleed99 n99 0 160000
Rser100 n99 ns100 0.0116542129168
Lser100 ns100 n100 8.07394192913e-08
Cbase100 n100 0 1.43536745407e-11
Rbleed100 n100 0 160000
Rser101 n100 ns101 0.0116542129168
Lser101 ns101 n101 8.07394192913e-08
Cbase101 n101 0 1.43536745407e-11
Rbleed101 n101 0 160000
Rser102 n101 ns102 0.0116542129168
Lser102 ns102 n102 8.07394192913e-08
Cbase102 n102 0 1.43536745407e-11
Rbleed102 n102 0 160000
Rser103 n102 ns103 0.0116542129168
Lser103 ns103 n103 8.07394192913e-08
Cbase103 n103 0 1.43536745407e-11
Rbleed103 n103 0 160000
Rser104 n103 ns104 0.0116542129168
Lser104 ns104 n104 8.07394192913e-08
Cbase104 n104 0 1.43536745407e-11
Rbleed104 n104 0 160000
Rser105 n104 ns105 0.0116542129168
Lser105 ns105 n105 8.07394192913e-08
Cbase105 n105 0 1.43536745407e-11
Rbleed105 n105 0 160000
Rser106 n105 ns106 0.0116542129168
Lser106 ns106 n106 8.07394192913e-08
Cbase106 n106 0 1.43536745407e-11
Rbleed106 n106 0 160000
Rser107 n106 ns107 0.0116542129168
Lser107 ns107 n107 8.07394192913e-08
Cbase107 n107 0 1.43536745407e-11
Rbleed107 n107 0 160000
Rser108 n107 ns108 0.0116542129168
Lser108 ns108 n108 8.07394192913e-08
Cbase108 n108 0 1.43536745407e-11
Rbleed108 n108 0 160000
Rser109 n108 ns109 0.0116542129168
Lser109 ns109 n109 8.07394192913e-08
Cbase109 n109 0 1.43536745407e-11
Rbleed109 n109 0 160000
Rser110 n109 ns110 0.0116542129168
Lser110 ns110 n110 8.07394192913e-08
Cbase110 n110 0 1.43536745407e-11
Rbleed110 n110 0 160000
Rser111 n110 ns111 0.0116542129168
Lser111 ns111 n111 8.07394192913e-08
Cbase111 n111 0 1.43536745407e-11
Rbleed111 n111 0 160000
Rser112 n111 ns112 0.0116542129168
Lser112 ns112 n112 8.07394192913e-08
Cbase112 n112 0 1.43536745407e-11
Rbleed112 n112 0 160000
Rser113 n112 ns113 0.0116542129168
Lser113 ns113 n113 8.07394192913e-08
Cbase113 n113 0 1.43536745407e-11
Rbleed113 n113 0 160000
Rser114 n113 ns114 0.0116542129168
Lser114 ns114 n114 8.07394192913e-08
Cbase114 n114 0 1.43536745407e-11
Rbleed114 n114 0 160000
Rser115 n114 ns115 0.0116542129168
Lser115 ns115 n115 8.07394192913e-08
Cbase115 n115 0 1.43536745407e-11
Rbleed115 n115 0 160000
Rser116 n115 ns116 0.0116542129168
Lser116 ns116 n116 8.07394192913e-08
Cbase116 n116 0 1.43536745407e-11
Rbleed116 n116 0 160000
Rser117 n116 ns117 0.0116542129168
Lser117 ns117 n117 8.07394192913e-08
Cbase117 n117 0 1.43536745407e-11
Rbleed117 n117 0 160000
Rser118 n117 ns118 0.0116542129168
Lser118 ns118 n118 8.07394192913e-08
Cbase118 n118 0 1.43536745407e-11
Rbleed118 n118 0 160000
Rser119 n118 ns119 0.0116542129168
Lser119 ns119 n119 8.07394192913e-08
Cbase119 n119 0 1.43536745407e-11
Rbleed119 n119 0 160000
Rser120 n119 ns120 0.0116542129168
Lser120 ns120 n120 8.07394192913e-08
Cbase120 n120 0 1.43536745407e-11
Rbleed120 n120 0 160000
Rser121 n120 ns121 0.0116542129168
Lser121 ns121 n121 8.07394192913e-08
Cbase121 n121 0 1.43536745407e-11
Rbleed121 n121 0 160000
Rser122 n121 ns122 0.0116542129168
Lser122 ns122 n122 8.07394192913e-08
Cbase122 n122 0 1.43536745407e-11
Rbleed122 n122 0 160000
Rser123 n122 ns123 0.0116542129168
Lser123 ns123 n123 8.07394192913e-08
Cbase123 n123 0 1.43536745407e-11
Rbleed123 n123 0 160000
Rser124 n123 ns124 0.0116542129168
Lser124 ns124 n124 8.07394192913e-08
Cbase124 n124 0 1.43536745407e-11
Rbleed124 n124 0 160000
Rser125 n124 ns125 0.0116542129168
Lser125 ns125 n125 8.07394192913e-08
Cbase125 n125 0 1.43536745407e-11
Rbleed125 n125 0 160000
Rser126 n125 ns126 0.0116542129168
Lser126 ns126 n126 8.07394192913e-08
Cbase126 n126 0 1.43536745407e-11
Rbleed126 n126 0 160000
Rser127 n126 ns127 0.0116542129168
Lser127 ns127 n127 8.07394192913e-08
Cbase127 n127 0 1.43536745407e-11
Rbleed127 n127 0 160000
Rser128 n127 ns128 0.0116542129168
Lser128 ns128 n128 8.07394192913e-08
Cbase128 n128 0 1.43536745407e-11
Rbleed128 n128 0 160000
Bmag56 n56 0 I={(1.10856941071)*kmag*V(n56)*V(n56)*V(n56)/(1+(V(n56)/7.5)**2) + gcore*V(n56)}
Bmag60 n60 0 I={(1.11127812129)*kmag*V(n60)*V(n60)*V(n60)/(1+(V(n60)/7.5)**2) + gcore*V(n60)}
Bmag64 n64 0 I={(1.11387817067)*kmag*V(n64)*V(n64)*V(n64)/(1+(V(n64)/7.5)**2) + gcore*V(n64)}
Bmag68 n68 0 I={(1.11636701995)*kmag*V(n68)*V(n68)*V(n68)/(1+(V(n68)/7.5)**2) + gcore*V(n68)}
Bmag72 n72 0 I={(1.11874223882)*kmag*V(n72)*V(n72)*V(n72)/(1+(V(n72)/7.5)**2) + gcore*V(n72)}
Bmag76 n76 0 I={(1.1210015079)*kmag*V(n76)*V(n76)*V(n76)/(1+(V(n76)/7.5)**2) + gcore*V(n76)}
Bmag80 n80 0 I={(1.12314262106)*kmag*V(n80)*V(n80)*V(n80)/(1+(V(n80)/7.5)**2) + gcore*V(n80)}
Bmag84 n84 0 I={(1.12516348754)*kmag*V(n84)*V(n84)*V(n84)/(1+(V(n84)/7.5)**2) + gcore*V(n84)}
Bmag88 n88 0 I={(1.12706213401)*kmag*V(n88)*V(n88)*V(n88)/(1+(V(n88)/7.5)**2) + gcore*V(n88)}
Bmag92 n92 0 I={(1.12883670645)*kmag*V(n92)*V(n92)*V(n92)/(1+(V(n92)/7.5)**2) + gcore*V(n92)}
Bmag96 n96 0 I={(1.13048547204)*kmag*V(n96)*V(n96)*V(n96)/(1+(V(n96)/7.5)**2) + gcore*V(n96)}
Bmag100 n100 0 I={(1.13200682077)*kmag*V(n100)*V(n100)*V(n100)/(1+(V(n100)/7.5)**2) + gcore*V(n100)}
Bmag104 n104 0 I={(1.13339926709)*kmag*V(n104)*V(n104)*V(n104)/(1+(V(n104)/7.5)**2) + gcore*V(n104)}
Bmag108 n108 0 I={(1.13466145129)*kmag*V(n108)*V(n108)*V(n108)/(1+(V(n108)/7.5)**2) + gcore*V(n108)}
Bmag112 n112 0 I={(1.13579214086)*kmag*V(n112)*V(n112)*V(n112)/(1+(V(n112)/7.5)**2) + gcore*V(n112)}
Bmag116 n116 0 I={(1.13679023171)*kmag*V(n116)*V(n116)*V(n116)/(1+(V(n116)/7.5)**2) + gcore*V(n116)}
Bmag120 n120 0 I={(1.13765474923)*kmag*V(n120)*V(n120)*V(n120)/(1+(V(n120)/7.5)**2) + gcore*V(n120)}
Bmag124 n124 0 I={(1.13838484922)*kmag*V(n124)*V(n124)*V(n124)/(1+(V(n124)/7.5)**2) + gcore*V(n124)}
Rlock50 n128 lk50r 21.5657104461
Llock50 lk50r lk50l 1.23562419076e-06
Clock50 lk50l 0 8.2e-12
Rlock100 n128 lk100r 14.2185399976
Llock100 lk100r lk100l 4.06112827865e-07
Clock100 lk100l 0 6.2e-12
Rext1 n128 ext1r 12.604784608
Lext1 ext1r ext1l 2.41943370087e-07
Cext1 ext1l v150s1 4.7e-12
Rload150_1 v150s1 0 190
Rext2 v150s1 ext2r 11.3189516954
Lext2 ext2r ext2l 2.78095827686e-07
Cext2 ext2l v150 4.089e-12
Rload150_2 v150 0 256.5
.control
set filetype=ascii
set wr_singlescale
set wr_vecnames
tran 5e-10 5.5e-07 0 2e-10
wrdata p026_h025_cascaded_128c_75ohm_tran.csv time v(n0) v(n64) v(v150) i(Vsrc) i(Vbias)
.endc
.end

* magnetic_only_tuned_extraction
* Hybrid purity lock-in: source-only 50 MHz, passive 150 MHz extraction.
* role=control; source_only=True; no direct 100/150 MHz discovery drive.
* extraction=single_high_q; stages=1; q_label=medium
.option method=gear maxord=2 reltol=2e-4 abstol=1e-12 vntol=1e-6 chgtol=1e-16 itl4=320
.model DVAR D(Is=1e-15 Rs=0.3 Cjo=1e-15 Vj=0.62 M=0.6 Bv=18 Ibv=1e-06)
.param kmag=1.56825e-06
.param gcore=1.35e-07
Vbias vb 0 DC 3.1
Vsrc src 0 SIN(0 2.6 50000000)
Rsrc src n0 75
Rrawload n96 0 300
Cbase0 n0 0 1.36701662292e-11
Rbleed0 n0 0 160000
Rser1 n0 ns1 0.0155389505558
Lser1 ns1 n1 7.68946850394e-08
Cbase1 n1 0 1.36701662292e-11
Rbleed1 n1 0 160000
Rser2 n1 ns2 0.0155389505558
Lser2 ns2 n2 7.68946850394e-08
Cbase2 n2 0 1.36701662292e-11
Rbleed2 n2 0 160000
Rser3 n2 ns3 0.0155389505558
Lser3 ns3 n3 7.68946850394e-08
Cbase3 n3 0 1.36701662292e-11
Rbleed3 n3 0 160000
Rser4 n3 ns4 0.0155389505558
Lser4 ns4 n4 7.68946850394e-08
Cbase4 n4 0 1.36701662292e-11
Rbleed4 n4 0 160000
Rser5 n4 ns5 0.0155389505558
Lser5 ns5 n5 7.68946850394e-08
Cbase5 n5 0 1.36701662292e-11
Rbleed5 n5 0 160000
Rser6 n5 ns6 0.0155389505558
Lser6 ns6 n6 7.68946850394e-08
Cbase6 n6 0 1.36701662292e-11
Rbleed6 n6 0 160000
Rser7 n6 ns7 0.0155389505558
Lser7 ns7 n7 7.68946850394e-08
Cbase7 n7 0 1.36701662292e-11
Rbleed7 n7 0 160000
Rser8 n7 ns8 0.0155389505558
Lser8 ns8 n8 7.68946850394e-08
Cbase8 n8 0 1.36701662292e-11
Rbleed8 n8 0 160000
Rser9 n8 ns9 0.0155389505558
Lser9 ns9 n9 7.68946850394e-08
Cbase9 n9 0 1.36701662292e-11
Rbleed9 n9 0 160000
Rser10 n9 ns10 0.0155389505558
Lser10 ns10 n10 7.68946850394e-08
Cbase10 n10 0 1.36701662292e-11
Rbleed10 n10 0 160000
Rser11 n10 ns11 0.0155389505558
Lser11 ns11 n11 7.68946850394e-08
Cbase11 n11 0 1.36701662292e-11
Rbleed11 n11 0 160000
Rser12 n11 ns12 0.0155389505558
Lser12 ns12 n12 7.68946850394e-08
Cbase12 n12 0 1.36701662292e-11
Rbleed12 n12 0 160000
Rser13 n12 ns13 0.0155389505558
Lser13 ns13 n13 7.68946850394e-08
Cbase13 n13 0 1.36701662292e-11
Rbleed13 n13 0 160000
Rser14 n13 ns14 0.0155389505558
Lser14 ns14 n14 7.68946850394e-08
Cbase14 n14 0 1.36701662292e-11
Rbleed14 n14 0 160000
Rser15 n14 ns15 0.0155389505558
Lser15 ns15 n15 7.68946850394e-08
Cbase15 n15 0 1.36701662292e-11
Rbleed15 n15 0 160000
Rser16 n15 ns16 0.0155389505558
Lser16 ns16 n16 7.68946850394e-08
Cbase16 n16 0 1.36701662292e-11
Rbleed16 n16 0 160000
Rser17 n16 ns17 0.0155389505558
Lser17 ns17 n17 7.68946850394e-08
Cbase17 n17 0 1.36701662292e-11
Rbleed17 n17 0 160000
Rser18 n17 ns18 0.0155389505558
Lser18 ns18 n18 7.68946850394e-08
Cbase18 n18 0 1.36701662292e-11
Rbleed18 n18 0 160000
Rser19 n18 ns19 0.0155389505558
Lser19 ns19 n19 7.68946850394e-08
Cbase19 n19 0 1.36701662292e-11
Rbleed19 n19 0 160000
Rser20 n19 ns20 0.0155389505558
Lser20 ns20 n20 7.68946850394e-08
Cbase20 n20 0 1.36701662292e-11
Rbleed20 n20 0 160000
Rser21 n20 ns21 0.0155389505558
Lser21 ns21 n21 7.68946850394e-08
Cbase21 n21 0 1.36701662292e-11
Rbleed21 n21 0 160000
Rser22 n21 ns22 0.0155389505558
Lser22 ns22 n22 7.68946850394e-08
Cbase22 n22 0 1.36701662292e-11
Rbleed22 n22 0 160000
Rser23 n22 ns23 0.0155389505558
Lser23 ns23 n23 7.68946850394e-08
Cbase23 n23 0 1.36701662292e-11
Rbleed23 n23 0 160000
Rser24 n23 ns24 0.0155389505558
Lser24 ns24 n24 7.68946850394e-08
Cbase24 n24 0 1.36701662292e-11
Rbleed24 n24 0 160000
Rser25 n24 ns25 0.0155389505558
Lser25 ns25 n25 7.68946850394e-08
Cbase25 n25 0 1.36701662292e-11
Rbleed25 n25 0 160000
Rser26 n25 ns26 0.0155389505558
Lser26 ns26 n26 7.68946850394e-08
Cbase26 n26 0 1.36701662292e-11
Rbleed26 n26 0 160000
Rser27 n26 ns27 0.0155389505558
Lser27 ns27 n27 7.68946850394e-08
Cbase27 n27 0 1.36701662292e-11
Rbleed27 n27 0 160000
Rser28 n27 ns28 0.0155389505558
Lser28 ns28 n28 7.68946850394e-08
Cbase28 n28 0 1.36701662292e-11
Rbleed28 n28 0 160000
Rser29 n28 ns29 0.0155389505558
Lser29 ns29 n29 7.68946850394e-08
Cbase29 n29 0 1.36701662292e-11
Rbleed29 n29 0 160000
Rser30 n29 ns30 0.0155389505558
Lser30 ns30 n30 7.68946850394e-08
Cbase30 n30 0 1.36701662292e-11
Rbleed30 n30 0 160000
Rser31 n30 ns31 0.0155389505558
Lser31 ns31 n31 7.68946850394e-08
Cbase31 n31 0 1.36701662292e-11
Rbleed31 n31 0 160000
Rser32 n31 ns32 0.0155389505558
Lser32 ns32 n32 7.68946850394e-08
Cbase32 n32 0 1.36701662292e-11
Rbleed32 n32 0 160000
Rser33 n32 ns33 0.0155389505558
Lser33 ns33 n33 7.68946850394e-08
Cbase33 n33 0 1.36701662292e-11
Rbleed33 n33 0 160000
Rser34 n33 ns34 0.0155389505558
Lser34 ns34 n34 7.68946850394e-08
Cbase34 n34 0 1.36701662292e-11
Rbleed34 n34 0 160000
Rser35 n34 ns35 0.0155389505558
Lser35 ns35 n35 7.68946850394e-08
Cbase35 n35 0 1.36701662292e-11
Rbleed35 n35 0 160000
Rser36 n35 ns36 0.0155389505558
Lser36 ns36 n36 7.68946850394e-08
Cbase36 n36 0 1.36701662292e-11
Rbleed36 n36 0 160000
Rser37 n36 ns37 0.0155389505558
Lser37 ns37 n37 7.68946850394e-08
Cbase37 n37 0 1.36701662292e-11
Rbleed37 n37 0 160000
Rser38 n37 ns38 0.0155389505558
Lser38 ns38 n38 7.68946850394e-08
Cbase38 n38 0 1.36701662292e-11
Rbleed38 n38 0 160000
Rser39 n38 ns39 0.0155389505558
Lser39 ns39 n39 7.68946850394e-08
Cbase39 n39 0 1.36701662292e-11
Rbleed39 n39 0 160000
Rser40 n39 ns40 0.0155389505558
Lser40 ns40 n40 7.68946850394e-08
Cbase40 n40 0 1.36701662292e-11
Rbleed40 n40 0 160000
Rser41 n40 ns41 0.0155389505558
Lser41 ns41 n41 7.68946850394e-08
Cbase41 n41 0 1.36701662292e-11
Rbleed41 n41 0 160000
Rser42 n41 ns42 0.0155389505558
Lser42 ns42 n42 7.68946850394e-08
Cbase42 n42 0 1.36701662292e-11
Rbleed42 n42 0 160000
Rser43 n42 ns43 0.0155389505558
Lser43 ns43 n43 7.68946850394e-08
Cbase43 n43 0 1.36701662292e-11
Rbleed43 n43 0 160000
Rser44 n43 ns44 0.0155389505558
Lser44 ns44 n44 7.68946850394e-08
Cbase44 n44 0 1.36701662292e-11
Rbleed44 n44 0 160000
Rser45 n44 ns45 0.0155389505558
Lser45 ns45 n45 7.68946850394e-08
Cbase45 n45 0 1.36701662292e-11
Rbleed45 n45 0 160000
Rser46 n45 ns46 0.0155389505558
Lser46 ns46 n46 7.68946850394e-08
Cbase46 n46 0 1.36701662292e-11
Rbleed46 n46 0 160000
Rser47 n46 ns47 0.0155389505558
Lser47 ns47 n47 7.68946850394e-08
Cbase47 n47 0 1.36701662292e-11
Rbleed47 n47 0 160000
Rser48 n47 ns48 0.0155389505558
Lser48 ns48 n48 7.68946850394e-08
Cbase48 n48 0 1.36701662292e-11
Rbleed48 n48 0 160000
Rser49 n48 ns49 0.0155389505558
Lser49 ns49 n49 7.68946850394e-08
Cbase49 n49 0 1.36701662292e-11
Rbleed49 n49 0 160000
Rser50 n49 ns50 0.0155389505558
Lser50 ns50 n50 7.68946850394e-08
Cbase50 n50 0 1.36701662292e-11
Rbleed50 n50 0 160000
Rser51 n50 ns51 0.0155389505558
Lser51 ns51 n51 7.68946850394e-08
Cbase51 n51 0 1.36701662292e-11
Rbleed51 n51 0 160000
Rser52 n51 ns52 0.0155389505558
Lser52 ns52 n52 7.68946850394e-08
Cbase52 n52 0 1.36701662292e-11
Rbleed52 n52 0 160000
Rser53 n52 ns53 0.0155389505558
Lser53 ns53 n53 7.68946850394e-08
Cbase53 n53 0 1.36701662292e-11
Rbleed53 n53 0 160000
Rser54 n53 ns54 0.0155389505558
Lser54 ns54 n54 7.68946850394e-08
Cbase54 n54 0 1.36701662292e-11
Rbleed54 n54 0 160000
Rser55 n54 ns55 0.0155389505558
Lser55 ns55 n55 7.68946850394e-08
Cbase55 n55 0 1.36701662292e-11
Rbleed55 n55 0 160000
Rser56 n55 ns56 0.0155389505558
Lser56 ns56 n56 7.68946850394e-08
Cbase56 n56 0 1.36701662292e-11
Rbleed56 n56 0 160000
Rser57 n56 ns57 0.0155389505558
Lser57 ns57 n57 7.68946850394e-08
Cbase57 n57 0 1.36701662292e-11
Rbleed57 n57 0 160000
Rser58 n57 ns58 0.0155389505558
Lser58 ns58 n58 7.68946850394e-08
Cbase58 n58 0 1.36701662292e-11
Rbleed58 n58 0 160000
Rser59 n58 ns59 0.0155389505558
Lser59 ns59 n59 7.68946850394e-08
Cbase59 n59 0 1.36701662292e-11
Rbleed59 n59 0 160000
Rser60 n59 ns60 0.0155389505558
Lser60 ns60 n60 7.68946850394e-08
Cbase60 n60 0 1.36701662292e-11
Rbleed60 n60 0 160000
Rser61 n60 ns61 0.0155389505558
Lser61 ns61 n61 7.68946850394e-08
Cbase61 n61 0 1.36701662292e-11
Rbleed61 n61 0 160000
Rser62 n61 ns62 0.0155389505558
Lser62 ns62 n62 7.68946850394e-08
Cbase62 n62 0 1.36701662292e-11
Rbleed62 n62 0 160000
Rser63 n62 ns63 0.0155389505558
Lser63 ns63 n63 7.68946850394e-08
Cbase63 n63 0 1.36701662292e-11
Rbleed63 n63 0 160000
Rser64 n63 ns64 0.0155389505558
Lser64 ns64 n64 7.68946850394e-08
Cbase64 n64 0 1.36701662292e-11
Rbleed64 n64 0 160000
Rser65 n64 ns65 0.0155389505558
Lser65 ns65 n65 7.68946850394e-08
Cbase65 n65 0 1.36701662292e-11
Rbleed65 n65 0 160000
Rser66 n65 ns66 0.0155389505558
Lser66 ns66 n66 7.68946850394e-08
Cbase66 n66 0 1.36701662292e-11
Rbleed66 n66 0 160000
Rser67 n66 ns67 0.0155389505558
Lser67 ns67 n67 7.68946850394e-08
Cbase67 n67 0 1.36701662292e-11
Rbleed67 n67 0 160000
Rser68 n67 ns68 0.0155389505558
Lser68 ns68 n68 7.68946850394e-08
Cbase68 n68 0 1.36701662292e-11
Rbleed68 n68 0 160000
Rser69 n68 ns69 0.0155389505558
Lser69 ns69 n69 7.68946850394e-08
Cbase69 n69 0 1.36701662292e-11
Rbleed69 n69 0 160000
Rser70 n69 ns70 0.0155389505558
Lser70 ns70 n70 7.68946850394e-08
Cbase70 n70 0 1.36701662292e-11
Rbleed70 n70 0 160000
Rser71 n70 ns71 0.0155389505558
Lser71 ns71 n71 7.68946850394e-08
Cbase71 n71 0 1.36701662292e-11
Rbleed71 n71 0 160000
Rser72 n71 ns72 0.0155389505558
Lser72 ns72 n72 7.68946850394e-08
Cbase72 n72 0 1.36701662292e-11
Rbleed72 n72 0 160000
Rser73 n72 ns73 0.0155389505558
Lser73 ns73 n73 7.68946850394e-08
Cbase73 n73 0 1.36701662292e-11
Rbleed73 n73 0 160000
Rser74 n73 ns74 0.0155389505558
Lser74 ns74 n74 7.68946850394e-08
Cbase74 n74 0 1.36701662292e-11
Rbleed74 n74 0 160000
Rser75 n74 ns75 0.0155389505558
Lser75 ns75 n75 7.68946850394e-08
Cbase75 n75 0 1.36701662292e-11
Rbleed75 n75 0 160000
Rser76 n75 ns76 0.0155389505558
Lser76 ns76 n76 7.68946850394e-08
Cbase76 n76 0 1.36701662292e-11
Rbleed76 n76 0 160000
Rser77 n76 ns77 0.0155389505558
Lser77 ns77 n77 7.68946850394e-08
Cbase77 n77 0 1.36701662292e-11
Rbleed77 n77 0 160000
Rser78 n77 ns78 0.0155389505558
Lser78 ns78 n78 7.68946850394e-08
Cbase78 n78 0 1.36701662292e-11
Rbleed78 n78 0 160000
Rser79 n78 ns79 0.0155389505558
Lser79 ns79 n79 7.68946850394e-08
Cbase79 n79 0 1.36701662292e-11
Rbleed79 n79 0 160000
Rser80 n79 ns80 0.0155389505558
Lser80 ns80 n80 7.68946850394e-08
Cbase80 n80 0 1.36701662292e-11
Rbleed80 n80 0 160000
Rser81 n80 ns81 0.0155389505558
Lser81 ns81 n81 7.68946850394e-08
Cbase81 n81 0 1.36701662292e-11
Rbleed81 n81 0 160000
Rser82 n81 ns82 0.0155389505558
Lser82 ns82 n82 7.68946850394e-08
Cbase82 n82 0 1.36701662292e-11
Rbleed82 n82 0 160000
Rser83 n82 ns83 0.0155389505558
Lser83 ns83 n83 7.68946850394e-08
Cbase83 n83 0 1.36701662292e-11
Rbleed83 n83 0 160000
Rser84 n83 ns84 0.0155389505558
Lser84 ns84 n84 7.68946850394e-08
Cbase84 n84 0 1.36701662292e-11
Rbleed84 n84 0 160000
Rser85 n84 ns85 0.0155389505558
Lser85 ns85 n85 7.68946850394e-08
Cbase85 n85 0 1.36701662292e-11
Rbleed85 n85 0 160000
Rser86 n85 ns86 0.0155389505558
Lser86 ns86 n86 7.68946850394e-08
Cbase86 n86 0 1.36701662292e-11
Rbleed86 n86 0 160000
Rser87 n86 ns87 0.0155389505558
Lser87 ns87 n87 7.68946850394e-08
Cbase87 n87 0 1.36701662292e-11
Rbleed87 n87 0 160000
Rser88 n87 ns88 0.0155389505558
Lser88 ns88 n88 7.68946850394e-08
Cbase88 n88 0 1.36701662292e-11
Rbleed88 n88 0 160000
Rser89 n88 ns89 0.0155389505558
Lser89 ns89 n89 7.68946850394e-08
Cbase89 n89 0 1.36701662292e-11
Rbleed89 n89 0 160000
Rser90 n89 ns90 0.0155389505558
Lser90 ns90 n90 7.68946850394e-08
Cbase90 n90 0 1.36701662292e-11
Rbleed90 n90 0 160000
Rser91 n90 ns91 0.0155389505558
Lser91 ns91 n91 7.68946850394e-08
Cbase91 n91 0 1.36701662292e-11
Rbleed91 n91 0 160000
Rser92 n91 ns92 0.0155389505558
Lser92 ns92 n92 7.68946850394e-08
Cbase92 n92 0 1.36701662292e-11
Rbleed92 n92 0 160000
Rser93 n92 ns93 0.0155389505558
Lser93 ns93 n93 7.68946850394e-08
Cbase93 n93 0 1.36701662292e-11
Rbleed93 n93 0 160000
Rser94 n93 ns94 0.0155389505558
Lser94 ns94 n94 7.68946850394e-08
Cbase94 n94 0 1.36701662292e-11
Rbleed94 n94 0 160000
Rser95 n94 ns95 0.0155389505558
Lser95 ns95 n95 7.68946850394e-08
Cbase95 n95 0 1.36701662292e-11
Rbleed95 n95 0 160000
Rser96 n95 ns96 0.0155389505558
Lser96 ns96 n96 7.68946850394e-08
Cbase96 n96 0 1.36701662292e-11
Rbleed96 n96 0 160000
Bmag42 n42 0 I={(1.10856941071)*kmag*V(n42)*V(n42)*V(n42)/(1+(V(n42)/7.5)**2) + gcore*V(n42)}
Bmag46 n46 0 I={(1.11215700547)*kmag*V(n46)*V(n46)*V(n46)/(1+(V(n46)/7.5)**2) + gcore*V(n46)}
Bmag50 n50 0 I={(1.11554991137)*kmag*V(n50)*V(n50)*V(n50)/(1+(V(n50)/7.5)**2) + gcore*V(n50)}
Bmag54 n54 0 I={(1.11874223882)*kmag*V(n54)*V(n54)*V(n54)/(1+(V(n54)/7.5)**2) + gcore*V(n54)}
Bmag58 n58 0 I={(1.12172844636)*kmag*V(n58)*V(n58)*V(n58)/(1+(V(n58)/7.5)**2) + gcore*V(n58)}
Bmag62 n62 0 I={(1.12450335037)*kmag*V(n62)*V(n62)*V(n62)/(1+(V(n62)/7.5)**2) + gcore*V(n62)}
Bmag66 n66 0 I={(1.12706213401)*kmag*V(n66)*V(n66)*V(n66)/(1+(V(n66)/7.5)**2) + gcore*V(n66)}
Bmag70 n70 0 I={(1.12940035557)*kmag*V(n70)*V(n70)*V(n70)/(1+(V(n70)/7.5)**2) + gcore*V(n70)}
Bmag74 n74 0 I={(1.13151395623)*kmag*V(n74)*V(n74)*V(n74)/(1+(V(n74)/7.5)**2) + gcore*V(n74)}
Bmag78 n78 0 I={(1.13339926709)*kmag*V(n78)*V(n78)*V(n78)/(1+(V(n78)/7.5)**2) + gcore*V(n78)}
Bmag82 n82 0 I={(1.1350530155)*kmag*V(n82)*V(n82)*V(n82)/(1+(V(n82)/7.5)**2) + gcore*V(n82)}
Bmag86 n86 0 I={(1.13647233079)*kmag*V(n86)*V(n86)*V(n86)/(1+(V(n86)/7.5)**2) + gcore*V(n86)}
Bmag90 n90 0 I={(1.13765474923)*kmag*V(n90)*V(n90)*V(n90)/(1+(V(n90)/7.5)**2) + gcore*V(n90)}
Bmag94 n94 0 I={(1.1385982183)*kmag*V(n94)*V(n94)*V(n94)/(1+(V(n94)/7.5)**2) + gcore*V(n94)}
Rlock50 n96 lk50r 21.5657104461
Llock50 lk50r lk50l 1.23562419076e-06
Clock50 lk50l 0 8.2e-12
Rlock100 n96 lk100r 14.2185399976
Llock100 lk100r lk100l 4.06112827865e-07
Clock100 lk100l 0 6.2e-12
Rext1 n96 ext1r 10.3130055883
Lext1 ext1r ext1l 2.41943370087e-07
Cext1 ext1l v150 4.7e-12
Rload150_1 v150 0 150
.control
set filetype=ascii
set wr_singlescale
set wr_vecnames
tran 5e-10 5.5e-07 0 2e-10
wrdata magnetic_only_tuned_extraction_tran.csv time v(n0) v(n48) v(v150) i(Vsrc) i(Vbias)
.endc
.end

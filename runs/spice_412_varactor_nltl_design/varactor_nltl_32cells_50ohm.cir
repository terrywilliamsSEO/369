* varactor_nltl_32cells_50ohm
* Varactor-loaded NLTL 4->8->12 bench design track.
* role=discovery; source_only=True; direct_100=False; direct_150=False
.option method=gear maxord=2 reltol=2e-4 abstol=1e-12 vntol=1e-6 chgtol=1e-16 itl4=200
.model DVAR D(Is=1e-15 Rs=0.85 Cjo=9.85306645317e-11 Vj=0.75 M=0.5 Bv=18 Ibv=1e-06)
Vbias vb 0 DC 4
Vsrc src 0 SIN(0 2 50000000)
Rsrc src n0 50
Rload n32 0 50
Cfixed0 n0 0 8.59436692696e-12
Dvar0 n0 vb DVAR
Rbleed0 n0 0 200000
Rser1 n0 ns1 0.035
Lser1 ns1 n1 1.19366207319e-07
Cfixed1 n1 0 8.59436692696e-12
Dvar1 n1 vb DVAR
Rbleed1 n1 0 200000
Rser2 n1 ns2 0.035
Lser2 ns2 n2 1.19366207319e-07
Cfixed2 n2 0 8.59436692696e-12
Dvar2 n2 vb DVAR
Rbleed2 n2 0 200000
Rser3 n2 ns3 0.035
Lser3 ns3 n3 1.19366207319e-07
Cfixed3 n3 0 8.59436692696e-12
Dvar3 n3 vb DVAR
Rbleed3 n3 0 200000
Rser4 n3 ns4 0.035
Lser4 ns4 n4 1.19366207319e-07
Cfixed4 n4 0 8.59436692696e-12
Dvar4 n4 vb DVAR
Rbleed4 n4 0 200000
Rser5 n4 ns5 0.035
Lser5 ns5 n5 1.19366207319e-07
Cfixed5 n5 0 8.59436692696e-12
Dvar5 n5 vb DVAR
Rbleed5 n5 0 200000
Rser6 n5 ns6 0.035
Lser6 ns6 n6 1.19366207319e-07
Cfixed6 n6 0 8.59436692696e-12
Dvar6 n6 vb DVAR
Rbleed6 n6 0 200000
Rser7 n6 ns7 0.035
Lser7 ns7 n7 1.19366207319e-07
Cfixed7 n7 0 8.59436692696e-12
Dvar7 n7 vb DVAR
Rbleed7 n7 0 200000
Rser8 n7 ns8 0.035
Lser8 ns8 n8 1.19366207319e-07
Cfixed8 n8 0 8.59436692696e-12
Dvar8 n8 vb DVAR
Rbleed8 n8 0 200000
Rser9 n8 ns9 0.035
Lser9 ns9 n9 1.19366207319e-07
Cfixed9 n9 0 8.59436692696e-12
Dvar9 n9 vb DVAR
Rbleed9 n9 0 200000
Rser10 n9 ns10 0.035
Lser10 ns10 n10 1.19366207319e-07
Cfixed10 n10 0 8.59436692696e-12
Dvar10 n10 vb DVAR
Rbleed10 n10 0 200000
Rser11 n10 ns11 0.035
Lser11 ns11 n11 1.19366207319e-07
Cfixed11 n11 0 8.59436692696e-12
Dvar11 n11 vb DVAR
Rbleed11 n11 0 200000
Rser12 n11 ns12 0.035
Lser12 ns12 n12 1.19366207319e-07
Cfixed12 n12 0 8.59436692696e-12
Dvar12 n12 vb DVAR
Rbleed12 n12 0 200000
Rser13 n12 ns13 0.035
Lser13 ns13 n13 1.19366207319e-07
Cfixed13 n13 0 8.59436692696e-12
Dvar13 n13 vb DVAR
Rbleed13 n13 0 200000
Rser14 n13 ns14 0.035
Lser14 ns14 n14 1.19366207319e-07
Cfixed14 n14 0 8.59436692696e-12
Dvar14 n14 vb DVAR
Rbleed14 n14 0 200000
Rser15 n14 ns15 0.035
Lser15 ns15 n15 1.19366207319e-07
Cfixed15 n15 0 8.59436692696e-12
Dvar15 n15 vb DVAR
Rbleed15 n15 0 200000
Rser16 n15 ns16 0.035
Lser16 ns16 n16 1.19366207319e-07
Cfixed16 n16 0 8.59436692696e-12
Dvar16 n16 vb DVAR
Rbleed16 n16 0 200000
Rser17 n16 ns17 0.035
Lser17 ns17 n17 1.19366207319e-07
Cfixed17 n17 0 8.59436692696e-12
Dvar17 n17 vb DVAR
Rbleed17 n17 0 200000
Rser18 n17 ns18 0.035
Lser18 ns18 n18 1.19366207319e-07
Cfixed18 n18 0 8.59436692696e-12
Dvar18 n18 vb DVAR
Rbleed18 n18 0 200000
Rser19 n18 ns19 0.035
Lser19 ns19 n19 1.19366207319e-07
Cfixed19 n19 0 8.59436692696e-12
Dvar19 n19 vb DVAR
Rbleed19 n19 0 200000
Rser20 n19 ns20 0.035
Lser20 ns20 n20 1.19366207319e-07
Cfixed20 n20 0 8.59436692696e-12
Dvar20 n20 vb DVAR
Rbleed20 n20 0 200000
Rser21 n20 ns21 0.035
Lser21 ns21 n21 1.19366207319e-07
Cfixed21 n21 0 8.59436692696e-12
Dvar21 n21 vb DVAR
Rbleed21 n21 0 200000
Rser22 n21 ns22 0.035
Lser22 ns22 n22 1.19366207319e-07
Cfixed22 n22 0 8.59436692696e-12
Dvar22 n22 vb DVAR
Rbleed22 n22 0 200000
Rser23 n22 ns23 0.035
Lser23 ns23 n23 1.19366207319e-07
Cfixed23 n23 0 8.59436692696e-12
Dvar23 n23 vb DVAR
Rbleed23 n23 0 200000
Rser24 n23 ns24 0.035
Lser24 ns24 n24 1.19366207319e-07
Cfixed24 n24 0 8.59436692696e-12
Dvar24 n24 vb DVAR
Rbleed24 n24 0 200000
Rser25 n24 ns25 0.035
Lser25 ns25 n25 1.19366207319e-07
Cfixed25 n25 0 8.59436692696e-12
Dvar25 n25 vb DVAR
Rbleed25 n25 0 200000
Rser26 n25 ns26 0.035
Lser26 ns26 n26 1.19366207319e-07
Cfixed26 n26 0 8.59436692696e-12
Dvar26 n26 vb DVAR
Rbleed26 n26 0 200000
Rser27 n26 ns27 0.035
Lser27 ns27 n27 1.19366207319e-07
Cfixed27 n27 0 8.59436692696e-12
Dvar27 n27 vb DVAR
Rbleed27 n27 0 200000
Rser28 n27 ns28 0.035
Lser28 ns28 n28 1.19366207319e-07
Cfixed28 n28 0 8.59436692696e-12
Dvar28 n28 vb DVAR
Rbleed28 n28 0 200000
Rser29 n28 ns29 0.035
Lser29 ns29 n29 1.19366207319e-07
Cfixed29 n29 0 8.59436692696e-12
Dvar29 n29 vb DVAR
Rbleed29 n29 0 200000
Rser30 n29 ns30 0.035
Lser30 ns30 n30 1.19366207319e-07
Cfixed30 n30 0 8.59436692696e-12
Dvar30 n30 vb DVAR
Rbleed30 n30 0 200000
Rser31 n30 ns31 0.035
Lser31 ns31 n31 1.19366207319e-07
Cfixed31 n31 0 8.59436692696e-12
Dvar31 n31 vb DVAR
Rbleed31 n31 0 200000
Rser32 n31 ns32 0.035
Lser32 ns32 n32 1.19366207319e-07
Cfixed32 n32 0 8.59436692696e-12
Dvar32 n32 vb DVAR
Rbleed32 n32 0 200000
.control
set filetype=ascii
set wr_singlescale
set wr_vecnames
tran 5e-10 5.5e-07 0 2e-10
wrdata varactor_nltl_32cells_50ohm_tran.csv time v(n0) v(n16) v(n32) i(Vsrc) i(Vbias)
.endc
.end

* tl_detuned_target_control
* Normalized LC transmission-line / waveguide-like 4->8->12 ladder.
* topology=tl_detuned_target_control role=control
.options reltol=3e-4 abstol=1e-8 chgtol=1e-12 method=gear maxord=2

Cs0 s0 0 1
Lress0 s0 0 0.00158314349441
Rlosss0 s0 0 14.2857142857
Ls0_1 s0 s1 0.000902439004841
Cs1 s1 0 1
Lress1 s1 0 0.00158314349441
Rlosss1 s1 0 14.2857142857
Ls1_2 s1 s2 0.000902439004841
Cs2 s2 0 1
Lress2 s2 0 0.00158314349441
Rlosss2 s2 0 14.2857142857
Ls2_3 s2 s3 0.000902439004841
Cs3 s3 0 1
Lress3 s3 0 0.00158314349441
Rlosss3 s3 0 14.2857142857
Ls3_4 s3 s4 0.000902439004841
Cs4 s4 0 1
Lress4 s4 0 0.00158314349441
Rlosss4 s4 0 14.2857142857
Ls4_5 s4 s5 0.000902439004841
Cs5 s5 0 1
Lress5 s5 0 0.00158314349441
Rlosss5 s5 0 14.2857142857
Ls5_6 s5 s6 0.000902439004841
Cs6 s6 0 1
Lress6 s6 0 0.00158314349441
Rlosss6 s6 0 14.2857142857
Ls6_7 s6 s7 0.000902439004841
Cs7 s7 0 1
Lress7 s7 0 0.00158314349441
Rlosss7 s7 0 14.2857142857
Ls7_8 s7 s8 0.000902439004841
Cs8 s8 0 1
Lress8 s8 0 0.00158314349441
Rlosss8 s8 0 14.2857142857
Ls8_9 s8 s9 0.000902439004841
Cs9 s9 0 1
Lress9 s9 0 0.00158314349441
Rlosss9 s9 0 14.2857142857
Ls9_10 s9 s10 0.000902439004841
Cs10 s10 0 1
Lress10 s10 0 0.00158314349441
Rlosss10 s10 0 14.2857142857
Ls10_11 s10 s11 0.000902439004841
Cs11 s11 0 1
Lress11 s11 0 0.00158314349441
Rlosss11 s11 0 14.2857142857
Ls11_12 s11 s12 0.000902439004841
Cs12 s12 0 1
Lress12 s12 0 0.00158314349441
Rlosss12 s12 0 14.2857142857
Ls12_13 s12 s13 0.000902439004841
Cs13 s13 0 1
Lress13 s13 0 0.00158314349441
Rlosss13 s13 0 14.2857142857
Ls13_14 s13 s14 0.000902439004841
Cs14 s14 0 1
Lress14 s14 0 0.00158314349441
Rlosss14 s14 0 14.2857142857
Ls14_15 s14 s15 0.000902439004841
Cs15 s15 0 1
Lress15 s15 0 0.00158314349441
Rlosss15 s15 0 14.2857142857
Ls15_16 s15 s16 0.000902439004841
Cs16 s16 0 1
Lress16 s16 0 0.00158314349441
Rlosss16 s16 0 14.2857142857
Ls16_17 s16 s17 0.000902439004841
Cs17 s17 0 1
Lress17 s17 0 0.00158314349441
Rlosss17 s17 0 14.2857142857
Ls17_18 s17 s18 0.000902439004841
Cs18 s18 0 1
Lress18 s18 0 0.00158314349441
Rlosss18 s18 0 14.2857142857
Ls18_19 s18 s19 0.000902439004841
Cs19 s19 0 1
Lress19 s19 0 0.00158314349441
Rlosss19 s19 0 14.2857142857
Ls19_20 s19 s20 0.000902439004841
Cs20 s20 0 1
Lress20 s20 0 0.00158314349441
Rlosss20 s20 0 14.2857142857
Ls20_21 s20 s21 0.000902439004841
Cs21 s21 0 1
Lress21 s21 0 0.00158314349441
Rlosss21 s21 0 14.2857142857
Ls21_22 s21 s22 0.000902439004841
Cs22 s22 0 1
Lress22 s22 0 0.00158314349441
Rlosss22 s22 0 14.2857142857
Ls22_23 s22 s23 0.000902439004841
Cs23 s23 0 1
Lress23 s23 0 0.00158314349441
Rlosss23 s23 0 14.2857142857
Ls23_24 s23 s24 0.000902439004841
Cs24 s24 0 1
Lress24 s24 0 0.00158314349441
Rlosss24 s24 0 14.2857142857
Ls24_25 s24 s25 0.000902439004841
Cs25 s25 0 1
Lress25 s25 0 0.00158314349441
Rlosss25 s25 0 14.2857142857
Ls25_26 s25 s26 0.000902439004841
Cs26 s26 0 1
Lress26 s26 0 0.00158314349441
Rlosss26 s26 0 14.2857142857
Ls26_27 s26 s27 0.000902439004841
Cs27 s27 0 1
Lress27 s27 0 0.00158314349441
Rlosss27 s27 0 14.2857142857
Ls27_28 s27 s28 0.000902439004841
Cs28 s28 0 1
Lress28 s28 0 0.00158314349441
Rlosss28 s28 0 14.2857142857
Ls28_29 s28 s29 0.000902439004841
Cs29 s29 0 1
Lress29 s29 0 0.00158314349441
Rlosss29 s29 0 14.2857142857
Ls29_30 s29 s30 0.000902439004841
Cs30 s30 0 1
Lress30 s30 0 0.00158314349441
Rlosss30 s30 0 14.2857142857
Ls30_31 s30 s31 0.000902439004841
Cs31 s31 0 1
Lress31 s31 0 0.00158314349441
Rlosss31 s31 0 14.2857142857
Rterms s31 0 0.180243735465
Cg0 g0 0 1
Lresg0 g0 0 0.000395785873603
Rlossg0 g0 0 14.2857142857
Lg0_1 g0 g1 0.000773834718443
Cg1 g1 0 1
Lresg1 g1 0 0.000395785873603
Rlossg1 g1 0 14.2857142857
Lg1_2 g1 g2 0.000773834718443
Cg2 g2 0 1
Lresg2 g2 0 0.000395785873603
Rlossg2 g2 0 14.2857142857
Lg2_3 g2 g3 0.000773834718443
Cg3 g3 0 1
Lresg3 g3 0 0.000395785873603
Rlossg3 g3 0 14.2857142857
Lg3_4 g3 g4 0.000773834718443
Cg4 g4 0 1
Lresg4 g4 0 0.000395785873603
Rlossg4 g4 0 14.2857142857
Lg4_5 g4 g5 0.000773834718443
Cg5 g5 0 1
Lresg5 g5 0 0.000395785873603
Rlossg5 g5 0 14.2857142857
Lg5_6 g5 g6 0.000773834718443
Cg6 g6 0 1
Lresg6 g6 0 0.000395785873603
Rlossg6 g6 0 14.2857142857
Lg6_7 g6 g7 0.000773834718443
Cg7 g7 0 1
Lresg7 g7 0 0.000395785873603
Rlossg7 g7 0 14.2857142857
Lg7_8 g7 g8 0.000773834718443
Cg8 g8 0 1
Lresg8 g8 0 0.000395785873603
Rlossg8 g8 0 14.2857142857
Lg8_9 g8 g9 0.000773834718443
Cg9 g9 0 1
Lresg9 g9 0 0.000395785873603
Rlossg9 g9 0 14.2857142857
Lg9_10 g9 g10 0.000773834718443
Cg10 g10 0 1
Lresg10 g10 0 0.000395785873603
Rlossg10 g10 0 14.2857142857
Lg10_11 g10 g11 0.000773834718443
Cg11 g11 0 1
Lresg11 g11 0 0.000395785873603
Rlossg11 g11 0 14.2857142857
Lg11_12 g11 g12 0.000773834718443
Cg12 g12 0 1
Lresg12 g12 0 0.000395785873603
Rlossg12 g12 0 14.2857142857
Lg12_13 g12 g13 0.000773834718443
Cg13 g13 0 1
Lresg13 g13 0 0.000395785873603
Rlossg13 g13 0 14.2857142857
Lg13_14 g13 g14 0.000773834718443
Cg14 g14 0 1
Lresg14 g14 0 0.000395785873603
Rlossg14 g14 0 14.2857142857
Lg14_15 g14 g15 0.000773834718443
Cg15 g15 0 1
Lresg15 g15 0 0.000395785873603
Rlossg15 g15 0 14.2857142857
Lg15_16 g15 g16 0.000773834718443
Cg16 g16 0 1
Lresg16 g16 0 0.000395785873603
Rlossg16 g16 0 14.2857142857
Lg16_17 g16 g17 0.000773834718443
Cg17 g17 0 1
Lresg17 g17 0 0.000395785873603
Rlossg17 g17 0 14.2857142857
Lg17_18 g17 g18 0.000773834718443
Cg18 g18 0 1
Lresg18 g18 0 0.000395785873603
Rlossg18 g18 0 14.2857142857
Lg18_19 g18 g19 0.000773834718443
Cg19 g19 0 1
Lresg19 g19 0 0.000395785873603
Rlossg19 g19 0 14.2857142857
Lg19_20 g19 g20 0.000773834718443
Cg20 g20 0 1
Lresg20 g20 0 0.000395785873603
Rlossg20 g20 0 14.2857142857
Lg20_21 g20 g21 0.000773834718443
Cg21 g21 0 1
Lresg21 g21 0 0.000395785873603
Rlossg21 g21 0 14.2857142857
Lg21_22 g21 g22 0.000773834718443
Cg22 g22 0 1
Lresg22 g22 0 0.000395785873603
Rlossg22 g22 0 14.2857142857
Lg22_23 g22 g23 0.000773834718443
Cg23 g23 0 1
Lresg23 g23 0 0.000395785873603
Rlossg23 g23 0 14.2857142857
Lg23_24 g23 g24 0.000773834718443
Cg24 g24 0 1
Lresg24 g24 0 0.000395785873603
Rlossg24 g24 0 14.2857142857
Lg24_25 g24 g25 0.000773834718443
Cg25 g25 0 1
Lresg25 g25 0 0.000395785873603
Rlossg25 g25 0 14.2857142857
Lg25_26 g25 g26 0.000773834718443
Cg26 g26 0 1
Lresg26 g26 0 0.000395785873603
Rlossg26 g26 0 14.2857142857
Lg26_27 g26 g27 0.000773834718443
Cg27 g27 0 1
Lresg27 g27 0 0.000395785873603
Rlossg27 g27 0 14.2857142857
Lg27_28 g27 g28 0.000773834718443
Cg28 g28 0 1
Lresg28 g28 0 0.000395785873603
Rlossg28 g28 0 14.2857142857
Lg28_29 g28 g29 0.000773834718443
Cg29 g29 0 1
Lresg29 g29 0 0.000395785873603
Rlossg29 g29 0 14.2857142857
Lg29_30 g29 g30 0.000773834718443
Cg30 g30 0 1
Lresg30 g30 0 0.000395785873603
Rlossg30 g30 0 14.2857142857
Lg30_31 g30 g31 0.000773834718443
Cg31 g31 0 1
Lresg31 g31 0 0.000395785873603
Rlossg31 g31 0 14.2857142857
Rtermg g31 0 0.166907309199
Ct0 t0 0 1
Lrest0 t0 0 0.000143198009557
Rlosst0 t0 0 14.2857142857
Lt0_1 t0 t1 0.000214246146539
Ct1 t1 0 1
Lrest1 t1 0 0.000143198009557
Rlosst1 t1 0 14.2857142857
Lt1_2 t1 t2 0.000214246146539
Ct2 t2 0 1
Lrest2 t2 0 0.000143198009557
Rlosst2 t2 0 14.2857142857
Lt2_3 t2 t3 0.000214246146539
Ct3 t3 0 1
Lrest3 t3 0 0.000143198009557
Rlosst3 t3 0 14.2857142857
Lt3_4 t3 t4 0.000214246146539
Ct4 t4 0 1
Lrest4 t4 0 0.000143198009557
Rlosst4 t4 0 14.2857142857
Lt4_5 t4 t5 0.000214246146539
Ct5 t5 0 1
Lrest5 t5 0 0.000143198009557
Rlosst5 t5 0 14.2857142857
Lt5_6 t5 t6 0.000214246146539
Ct6 t6 0 1
Lrest6 t6 0 0.000143198009557
Rlosst6 t6 0 14.2857142857
Lt6_7 t6 t7 0.000214246146539
Ct7 t7 0 1
Lrest7 t7 0 0.000143198009557
Rlosst7 t7 0 14.2857142857
Lt7_8 t7 t8 0.000214246146539
Ct8 t8 0 1
Lrest8 t8 0 0.000143198009557
Rlosst8 t8 0 14.2857142857
Lt8_9 t8 t9 0.000214246146539
Ct9 t9 0 1
Lrest9 t9 0 0.000143198009557
Rlosst9 t9 0 14.2857142857
Lt9_10 t9 t10 0.000214246146539
Ct10 t10 0 1
Lrest10 t10 0 0.000143198009557
Rlosst10 t10 0 14.2857142857
Lt10_11 t10 t11 0.000214246146539
Ct11 t11 0 1
Lrest11 t11 0 0.000143198009557
Rlosst11 t11 0 14.2857142857
Lt11_12 t11 t12 0.000214246146539
Ct12 t12 0 1
Lrest12 t12 0 0.000143198009557
Rlosst12 t12 0 14.2857142857
Lt12_13 t12 t13 0.000214246146539
Ct13 t13 0 1
Lrest13 t13 0 0.000143198009557
Rlosst13 t13 0 14.2857142857
Lt13_14 t13 t14 0.000214246146539
Ct14 t14 0 1
Lrest14 t14 0 0.000143198009557
Rlosst14 t14 0 14.2857142857
Lt14_15 t14 t15 0.000214246146539
Ct15 t15 0 1
Lrest15 t15 0 0.000143198009557
Rlosst15 t15 0 14.2857142857
Lt15_16 t15 t16 0.000214246146539
Ct16 t16 0 1
Lrest16 t16 0 0.000143198009557
Rlosst16 t16 0 14.2857142857
Lt16_17 t16 t17 0.000214246146539
Ct17 t17 0 1
Lrest17 t17 0 0.000143198009557
Rlosst17 t17 0 14.2857142857
Lt17_18 t17 t18 0.000214246146539
Ct18 t18 0 1
Lrest18 t18 0 0.000143198009557
Rlosst18 t18 0 14.2857142857
Lt18_19 t18 t19 0.000214246146539
Ct19 t19 0 1
Lrest19 t19 0 0.000143198009557
Rlosst19 t19 0 14.2857142857
Lt19_20 t19 t20 0.000214246146539
Ct20 t20 0 1
Lrest20 t20 0 0.000143198009557
Rlosst20 t20 0 14.2857142857
Lt20_21 t20 t21 0.000214246146539
Ct21 t21 0 1
Lrest21 t21 0 0.000143198009557
Rlosst21 t21 0 14.2857142857
Lt21_22 t21 t22 0.000214246146539
Ct22 t22 0 1
Lrest22 t22 0 0.000143198009557
Rlosst22 t22 0 14.2857142857
Lt22_23 t22 t23 0.000214246146539
Ct23 t23 0 1
Lrest23 t23 0 0.000143198009557
Rlosst23 t23 0 14.2857142857
Lt23_24 t23 t24 0.000214246146539
Ct24 t24 0 1
Lrest24 t24 0 0.000143198009557
Rlosst24 t24 0 14.2857142857
Lt24_25 t24 t25 0.000214246146539
Ct25 t25 0 1
Lrest25 t25 0 0.000143198009557
Rlosst25 t25 0 14.2857142857
Lt25_26 t25 t26 0.000214246146539
Ct26 t26 0 1
Lrest26 t26 0 0.000143198009557
Rlosst26 t26 0 14.2857142857
Lt26_27 t26 t27 0.000214246146539
Ct27 t27 0 1
Lrest27 t27 0 0.000143198009557
Rlosst27 t27 0 14.2857142857
Lt27_28 t27 t28 0.000214246146539
Ct28 t28 0 1
Lrest28 t28 0 0.000143198009557
Rlosst28 t28 0 14.2857142857
Lt28_29 t28 t29 0.000214246146539
Ct29 t29 0 1
Lrest29 t29 0 0.000143198009557
Rlosst29 t29 0 14.2857142857
Lt29_30 t29 t30 0.000214246146539
Ct30 t30 0 1
Lrest30 t30 0 0.000143198009557
Rlosst30 t30 0 14.2857142857
Lt30_31 t30 t31 0.000214246146539
Ct31 t31 0 1
Lrest31 t31 0 0.000143198009557
Rlosst31 t31 0 14.2857142857
Rtermt t31 0 0.0878228972159
Ccsg0 s0 g0 0.012
Ccgt0 g0 t0 0.009
Ccsg1 s1 g1 0.012
Ccgt1 g1 t1 0.009
Ccsg2 s2 g2 0.012
Ccgt2 g2 t2 0.009
Ccsg3 s3 g3 0.012
Ccgt3 g3 t3 0.009
Ccsg4 s4 g4 0.012
Ccgt4 g4 t4 0.009
Ccsg5 s5 g5 0.012
Ccgt5 g5 t5 0.009
Ccsg6 s6 g6 0.012
Ccgt6 g6 t6 0.009
Ccsg7 s7 g7 0.012
Ccgt7 g7 t7 0.009
Ccsg8 s8 g8 0.012
Ccgt8 g8 t8 0.009
Ccsg9 s9 g9 0.012
Ccgt9 g9 t9 0.009
Ccsg10 s10 g10 0.012
Ccgt10 g10 t10 0.009
Ccsg11 s11 g11 0.012
Ccgt11 g11 t11 0.009
Ccsg12 s12 g12 0.012
Ccgt12 g12 t12 0.009
Ccsg13 s13 g13 0.012
Ccgt13 g13 t13 0.009
Ccsg14 s14 g14 0.012
Ccgt14 g14 t14 0.009
Ccsg15 s15 g15 0.012
Ccgt15 g15 t15 0.009
Ccsg16 s16 g16 0.012
Ccgt16 g16 t16 0.009
Ccsg17 s17 g17 0.012
Ccgt17 g17 t17 0.009
Ccsg18 s18 g18 0.012
Ccgt18 g18 t18 0.009
Ccsg19 s19 g19 0.012
Ccgt19 g19 t19 0.009
Ccsg20 s20 g20 0.012
Ccgt20 g20 t20 0.009
Ccsg21 s21 g21 0.012
Ccgt21 g21 t21 0.009
Ccsg22 s22 g22 0.012
Ccgt22 g22 t22 0.009
Ccsg23 s23 g23 0.012
Ccgt23 g23 t23 0.009
Ccsg24 s24 g24 0.012
Ccgt24 g24 t24 0.009
Ccsg25 s25 g25 0.012
Ccgt25 g25 t25 0.009
Ccsg26 s26 g26 0.012
Ccgt26 g26 t26 0.009
Ccsg27 s27 g27 0.012
Ccgt27 g27 t27 0.009
Ccsg28 s28 g28 0.012
Ccgt28 g28 t28 0.009
Ccsg29 s29 g29 0.012
Ccgt29 g29 t29 0.009
Ccsg30 s30 g30 0.012
Ccgt30 g30 t30 0.009
Ccsg31 s31 g31 0.012
Ccgt31 g31 t31 0.009
Bmix8_0 g0 0 I={-(2.4*V(s0)*V(s0)*cos(0))}
Bmix12_0 t0 0 I={-(16*V(s0)*V(g0)*cos(0))}
Bsat0 t0 0 I={ 0.01*V(t0)*(V(s0)*V(s0)+V(g0)*V(g0)+V(t0)*V(t0)) }
Bmix8_1 g1 0 I={-(2.4*V(s1)*V(s1)*cos(0))}
Bmix12_1 t1 0 I={-(16*V(s1)*V(g1)*cos(0.890322580645))}
Bsat1 t1 0 I={ 0.01*V(t1)*(V(s1)*V(s1)+V(g1)*V(g1)+V(t1)*V(t1)) }
Bmix8_2 g2 0 I={-(2.4*V(s2)*V(s2)*cos(0))}
Bmix12_2 t2 0 I={-(16*V(s2)*V(g2)*cos(1.78064516129))}
Bsat2 t2 0 I={ 0.01*V(t2)*(V(s2)*V(s2)+V(g2)*V(g2)+V(t2)*V(t2)) }
Bmix8_3 g3 0 I={-(2.4*V(s3)*V(s3)*cos(0))}
Bmix12_3 t3 0 I={-(16*V(s3)*V(g3)*cos(2.67096774194))}
Bsat3 t3 0 I={ 0.01*V(t3)*(V(s3)*V(s3)+V(g3)*V(g3)+V(t3)*V(t3)) }
Bmix8_4 g4 0 I={-(2.4*V(s4)*V(s4)*cos(0))}
Bmix12_4 t4 0 I={-(16*V(s4)*V(g4)*cos(3.56129032258))}
Bsat4 t4 0 I={ 0.01*V(t4)*(V(s4)*V(s4)+V(g4)*V(g4)+V(t4)*V(t4)) }
Bmix8_5 g5 0 I={-(2.4*V(s5)*V(s5)*cos(0))}
Bmix12_5 t5 0 I={-(16*V(s5)*V(g5)*cos(4.45161290323))}
Bsat5 t5 0 I={ 0.01*V(t5)*(V(s5)*V(s5)+V(g5)*V(g5)+V(t5)*V(t5)) }
Bmix8_6 g6 0 I={-(2.4*V(s6)*V(s6)*cos(0))}
Bmix12_6 t6 0 I={-(16*V(s6)*V(g6)*cos(5.34193548387))}
Bsat6 t6 0 I={ 0.01*V(t6)*(V(s6)*V(s6)+V(g6)*V(g6)+V(t6)*V(t6)) }
Bmix8_7 g7 0 I={-(2.4*V(s7)*V(s7)*cos(0))}
Bmix12_7 t7 0 I={-(16*V(s7)*V(g7)*cos(6.23225806452))}
Bsat7 t7 0 I={ 0.01*V(t7)*(V(s7)*V(s7)+V(g7)*V(g7)+V(t7)*V(t7)) }
Bmix8_8 g8 0 I={-(2.4*V(s8)*V(s8)*cos(0))}
Bmix12_8 t8 0 I={-(16*V(s8)*V(g8)*cos(7.12258064516))}
Bsat8 t8 0 I={ 0.01*V(t8)*(V(s8)*V(s8)+V(g8)*V(g8)+V(t8)*V(t8)) }
Bmix8_9 g9 0 I={-(2.4*V(s9)*V(s9)*cos(0))}
Bmix12_9 t9 0 I={-(16*V(s9)*V(g9)*cos(8.01290322581))}
Bsat9 t9 0 I={ 0.01*V(t9)*(V(s9)*V(s9)+V(g9)*V(g9)+V(t9)*V(t9)) }
Bmix8_10 g10 0 I={-(2.4*V(s10)*V(s10)*cos(0))}
Bmix12_10 t10 0 I={-(16*V(s10)*V(g10)*cos(8.90322580645))}
Bsat10 t10 0 I={ 0.01*V(t10)*(V(s10)*V(s10)+V(g10)*V(g10)+V(t10)*V(t10)) }
Bmix8_11 g11 0 I={-(2.4*V(s11)*V(s11)*cos(0))}
Bmix12_11 t11 0 I={-(16*V(s11)*V(g11)*cos(9.7935483871))}
Bsat11 t11 0 I={ 0.01*V(t11)*(V(s11)*V(s11)+V(g11)*V(g11)+V(t11)*V(t11)) }
Bmix8_12 g12 0 I={-(2.4*V(s12)*V(s12)*cos(0))}
Bmix12_12 t12 0 I={-(16*V(s12)*V(g12)*cos(10.6838709677))}
Bsat12 t12 0 I={ 0.01*V(t12)*(V(s12)*V(s12)+V(g12)*V(g12)+V(t12)*V(t12)) }
Bmix8_13 g13 0 I={-(2.4*V(s13)*V(s13)*cos(0))}
Bmix12_13 t13 0 I={-(16*V(s13)*V(g13)*cos(11.5741935484))}
Bsat13 t13 0 I={ 0.01*V(t13)*(V(s13)*V(s13)+V(g13)*V(g13)+V(t13)*V(t13)) }
Bmix8_14 g14 0 I={-(2.4*V(s14)*V(s14)*cos(0))}
Bmix12_14 t14 0 I={-(16*V(s14)*V(g14)*cos(12.464516129))}
Bsat14 t14 0 I={ 0.01*V(t14)*(V(s14)*V(s14)+V(g14)*V(g14)+V(t14)*V(t14)) }
Bmix8_15 g15 0 I={-(2.4*V(s15)*V(s15)*cos(0))}
Bmix12_15 t15 0 I={-(16*V(s15)*V(g15)*cos(13.3548387097))}
Bsat15 t15 0 I={ 0.01*V(t15)*(V(s15)*V(s15)+V(g15)*V(g15)+V(t15)*V(t15)) }
Bmix8_16 g16 0 I={-(2.4*V(s16)*V(s16)*cos(0))}
Bmix12_16 t16 0 I={-(16*V(s16)*V(g16)*cos(14.2451612903))}
Bsat16 t16 0 I={ 0.01*V(t16)*(V(s16)*V(s16)+V(g16)*V(g16)+V(t16)*V(t16)) }
Bmix8_17 g17 0 I={-(2.4*V(s17)*V(s17)*cos(0))}
Bmix12_17 t17 0 I={-(16*V(s17)*V(g17)*cos(15.135483871))}
Bsat17 t17 0 I={ 0.01*V(t17)*(V(s17)*V(s17)+V(g17)*V(g17)+V(t17)*V(t17)) }
Bmix8_18 g18 0 I={-(2.4*V(s18)*V(s18)*cos(0))}
Bmix12_18 t18 0 I={-(16*V(s18)*V(g18)*cos(16.0258064516))}
Bsat18 t18 0 I={ 0.01*V(t18)*(V(s18)*V(s18)+V(g18)*V(g18)+V(t18)*V(t18)) }
Bmix8_19 g19 0 I={-(2.4*V(s19)*V(s19)*cos(0))}
Bmix12_19 t19 0 I={-(16*V(s19)*V(g19)*cos(16.9161290323))}
Bsat19 t19 0 I={ 0.01*V(t19)*(V(s19)*V(s19)+V(g19)*V(g19)+V(t19)*V(t19)) }
Bmix8_20 g20 0 I={-(2.4*V(s20)*V(s20)*cos(0))}
Bmix12_20 t20 0 I={-(16*V(s20)*V(g20)*cos(17.8064516129))}
Bsat20 t20 0 I={ 0.01*V(t20)*(V(s20)*V(s20)+V(g20)*V(g20)+V(t20)*V(t20)) }
Bmix8_21 g21 0 I={-(2.4*V(s21)*V(s21)*cos(0))}
Bmix12_21 t21 0 I={-(16*V(s21)*V(g21)*cos(18.6967741935))}
Bsat21 t21 0 I={ 0.01*V(t21)*(V(s21)*V(s21)+V(g21)*V(g21)+V(t21)*V(t21)) }
Bmix8_22 g22 0 I={-(2.4*V(s22)*V(s22)*cos(0))}
Bmix12_22 t22 0 I={-(16*V(s22)*V(g22)*cos(19.5870967742))}
Bsat22 t22 0 I={ 0.01*V(t22)*(V(s22)*V(s22)+V(g22)*V(g22)+V(t22)*V(t22)) }
Bmix8_23 g23 0 I={-(2.4*V(s23)*V(s23)*cos(0))}
Bmix12_23 t23 0 I={-(16*V(s23)*V(g23)*cos(20.4774193548))}
Bsat23 t23 0 I={ 0.01*V(t23)*(V(s23)*V(s23)+V(g23)*V(g23)+V(t23)*V(t23)) }
Bmix8_24 g24 0 I={-(2.4*V(s24)*V(s24)*cos(0))}
Bmix12_24 t24 0 I={-(16*V(s24)*V(g24)*cos(21.3677419355))}
Bsat24 t24 0 I={ 0.01*V(t24)*(V(s24)*V(s24)+V(g24)*V(g24)+V(t24)*V(t24)) }
Bmix8_25 g25 0 I={-(2.4*V(s25)*V(s25)*cos(0))}
Bmix12_25 t25 0 I={-(16*V(s25)*V(g25)*cos(22.2580645161))}
Bsat25 t25 0 I={ 0.01*V(t25)*(V(s25)*V(s25)+V(g25)*V(g25)+V(t25)*V(t25)) }
Bmix8_26 g26 0 I={-(2.4*V(s26)*V(s26)*cos(0))}
Bmix12_26 t26 0 I={-(16*V(s26)*V(g26)*cos(23.1483870968))}
Bsat26 t26 0 I={ 0.01*V(t26)*(V(s26)*V(s26)+V(g26)*V(g26)+V(t26)*V(t26)) }
Bmix8_27 g27 0 I={-(2.4*V(s27)*V(s27)*cos(0))}
Bmix12_27 t27 0 I={-(16*V(s27)*V(g27)*cos(24.0387096774))}
Bsat27 t27 0 I={ 0.01*V(t27)*(V(s27)*V(s27)+V(g27)*V(g27)+V(t27)*V(t27)) }
Bmix8_28 g28 0 I={-(2.4*V(s28)*V(s28)*cos(0))}
Bmix12_28 t28 0 I={-(16*V(s28)*V(g28)*cos(24.9290322581))}
Bsat28 t28 0 I={ 0.01*V(t28)*(V(s28)*V(s28)+V(g28)*V(g28)+V(t28)*V(t28)) }
Bmix8_29 g29 0 I={-(2.4*V(s29)*V(s29)*cos(0))}
Bmix12_29 t29 0 I={-(16*V(s29)*V(g29)*cos(25.8193548387))}
Bsat29 t29 0 I={ 0.01*V(t29)*(V(s29)*V(s29)+V(g29)*V(g29)+V(t29)*V(t29)) }
Bmix8_30 g30 0 I={-(2.4*V(s30)*V(s30)*cos(0))}
Bmix12_30 t30 0 I={-(16*V(s30)*V(g30)*cos(26.7096774194))}
Bsat30 t30 0 I={ 0.01*V(t30)*(V(s30)*V(s30)+V(g30)*V(g30)+V(t30)*V(t30)) }
Bmix8_31 g31 0 I={-(2.4*V(s31)*V(s31)*cos(0))}
Bmix12_31 t31 0 I={-(16*V(s31)*V(g31)*cos(27.6))}
Bsat31 t31 0 I={ 0.01*V(t31)*(V(s31)*V(s31)+V(g31)*V(g31)+V(t31)*V(t31)) }

Vdrive4 vin4 0 SIN(0 0.7 4)
Rdrive4 vin4 s0 0.0300406225775
Bobs4 obs4 0 V={(3.60541118673e-06*V(s0)+6.94606240843e-06*V(s1)+1.30974088209e-05*V(s2)+2.41710162372e-05*V(s3)+4.36583441612e-05*V(s4)+7.71795840655e-05*V(s5)+0.000133536635865*V(s6)+0.000226131598091*V(s7)+0.000374787326302*V(s8)+0.000607954902147*V(s9)+0.000965207430274*V(s10)+0.00149979800631*V(s11)+0.00228090769857*V(s12)+0.00339504452095*V(s13)+0.00494590830132*V(s14)+0.00705195399059*V(s15)+0.0098409200563*V(s16)+0.0134407889282*V(s17)+0.017967044439*V(s18)+0.0235066827753*V(s19)+0.0301001648913*V(s20)+0.0377232608352*V(s21)+0.0462713746585*V(s22)+0.05554927576*V(s23)+0.0652690398216*V(s24)+0.0750583252914*V(s25)+0.0844798900902*V(s26)+0.0930616254469*V(s27)+0.100334606342*V(s28)+0.105875065492*V(s29)+0.10934513284*V(s30)+0.110526914094*V(s31))}
Bobs8 obs8 0 V={(3.60541118673e-06*V(g0)+6.94606240843e-06*V(g1)+1.30974088209e-05*V(g2)+2.41710162372e-05*V(g3)+4.36583441612e-05*V(g4)+7.71795840655e-05*V(g5)+0.000133536635865*V(g6)+0.000226131598091*V(g7)+0.000374787326302*V(g8)+0.000607954902147*V(g9)+0.000965207430274*V(g10)+0.00149979800631*V(g11)+0.00228090769857*V(g12)+0.00339504452095*V(g13)+0.00494590830132*V(g14)+0.00705195399059*V(g15)+0.0098409200563*V(g16)+0.0134407889282*V(g17)+0.017967044439*V(g18)+0.0235066827753*V(g19)+0.0301001648913*V(g20)+0.0377232608352*V(g21)+0.0462713746585*V(g22)+0.05554927576*V(g23)+0.0652690398216*V(g24)+0.0750583252914*V(g25)+0.0844798900902*V(g26)+0.0930616254469*V(g27)+0.100334606342*V(g28)+0.105875065492*V(g29)+0.10934513284*V(g30)+0.110526914094*V(g31))}
Bobs12 obs12 0 V={(3.60541118673e-06*V(t0)+6.94606240843e-06*V(t1)+1.30974088209e-05*V(t2)+2.41710162372e-05*V(t3)+4.36583441612e-05*V(t4)+7.71795840655e-05*V(t5)+0.000133536635865*V(t6)+0.000226131598091*V(t7)+0.000374787326302*V(t8)+0.000607954902147*V(t9)+0.000965207430274*V(t10)+0.00149979800631*V(t11)+0.00228090769857*V(t12)+0.00339504452095*V(t13)+0.00494590830132*V(t14)+0.00705195399059*V(t15)+0.0098409200563*V(t16)+0.0134407889282*V(t17)+0.017967044439*V(t18)+0.0235066827753*V(t19)+0.0301001648913*V(t20)+0.0377232608352*V(t21)+0.0462713746585*V(t22)+0.05554927576*V(t23)+0.0652690398216*V(t24)+0.0750583252914*V(t25)+0.0844798900902*V(t26)+0.0930616254469*V(t27)+0.100334606342*V(t28)+0.105875065492*V(t29)+0.10934513284*V(t30)+0.110526914094*V(t31))}

.control
set noaskquit
set filetype=ascii
tran 0.002 32 0 0.002 uic
wrdata tl_detuned_target_control_tran.csv time v(obs4) v(obs8) v(obs12)
quit
.endc
.end

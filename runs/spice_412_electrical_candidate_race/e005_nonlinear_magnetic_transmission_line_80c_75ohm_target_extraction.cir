* e005_nonlinear_magnetic_transmission_line_80c_75ohm_target_extraction
* electrical_family=nonlinear_magnetic_transmission_line
* behavioral helpers are scored; no direct 100 MHz or 150 MHz source appears in discovery rows.
* qpm_sign_flip=False; alternating_sections=False; varactor_stack=single
* role=discovery; cleanup=target_extraction; source_only=True
.option method=gear maxord=2 reltol=2e-4 abstol=1e-12 vntol=1e-6 chgtol=1e-16 itl4=240
.model DVAR D(Is=1e-15 Rs=0.45 Cjo=1e-15 Vj=0.65 M=0.58 Bv=18 Ibv=1e-06)
Vbias vb 0 DC 3.4
Vsrc src 0 SIN(0 2.8 50000000)
Rsrc src n0 75
Rrawload n80 0 225
Cbase0 n0 0 2.5e-11
Rbleed0 n0 0 200000
Rser1 n0 ns1 0.034292856399
Lser1 ns1 n1 1.40625e-07
Cbase1 n1 0 2.5e-11
Rbleed1 n1 0 200000
Rser2 n1 ns2 0.034292856399
Lser2 ns2 n2 1.40625e-07
Cbase2 n2 0 2.5e-11
Rbleed2 n2 0 200000
Rser3 n2 ns3 0.034292856399
Lser3 ns3 n3 1.40625e-07
Cbase3 n3 0 2.5e-11
Rbleed3 n3 0 200000
Rser4 n3 ns4 0.034292856399
Lser4 ns4 n4 1.40625e-07
Cbase4 n4 0 2.5e-11
Rbleed4 n4 0 200000
Rser5 n4 ns5 0.034292856399
Lser5 ns5 n5 1.40625e-07
Cbase5 n5 0 2.5e-11
Rbleed5 n5 0 200000
Rser6 n5 ns6 0.034292856399
Lser6 ns6 n6 1.40625e-07
Cbase6 n6 0 2.5e-11
Rbleed6 n6 0 200000
Rser7 n6 ns7 0.034292856399
Lser7 ns7 n7 1.40625e-07
Cbase7 n7 0 2.5e-11
Rbleed7 n7 0 200000
Rser8 n7 ns8 0.034292856399
Lser8 ns8 n8 1.40625e-07
Cbase8 n8 0 2.5e-11
Rbleed8 n8 0 200000
Rser9 n8 ns9 0.034292856399
Lser9 ns9 n9 1.40625e-07
Cbase9 n9 0 2.5e-11
Rbleed9 n9 0 200000
Rser10 n9 ns10 0.034292856399
Lser10 ns10 n10 1.40625e-07
Cbase10 n10 0 2.5e-11
Rbleed10 n10 0 200000
Rser11 n10 ns11 0.034292856399
Lser11 ns11 n11 1.40625e-07
Cbase11 n11 0 2.5e-11
Rbleed11 n11 0 200000
Rser12 n11 ns12 0.034292856399
Lser12 ns12 n12 1.40625e-07
Cbase12 n12 0 2.5e-11
Rbleed12 n12 0 200000
Rser13 n12 ns13 0.034292856399
Lser13 ns13 n13 1.40625e-07
Cbase13 n13 0 2.5e-11
Rbleed13 n13 0 200000
Rser14 n13 ns14 0.034292856399
Lser14 ns14 n14 1.40625e-07
Cbase14 n14 0 2.5e-11
Rbleed14 n14 0 200000
Rser15 n14 ns15 0.034292856399
Lser15 ns15 n15 1.40625e-07
Cbase15 n15 0 2.5e-11
Rbleed15 n15 0 200000
Rser16 n15 ns16 0.034292856399
Lser16 ns16 n16 1.40625e-07
Cbase16 n16 0 2.5e-11
Rbleed16 n16 0 200000
Rser17 n16 ns17 0.034292856399
Lser17 ns17 n17 1.40625e-07
Cbase17 n17 0 2.5e-11
Rbleed17 n17 0 200000
Rser18 n17 ns18 0.034292856399
Lser18 ns18 n18 1.40625e-07
Cbase18 n18 0 2.5e-11
Rbleed18 n18 0 200000
Rser19 n18 ns19 0.034292856399
Lser19 ns19 n19 1.40625e-07
Cbase19 n19 0 2.5e-11
Rbleed19 n19 0 200000
Rser20 n19 ns20 0.034292856399
Lser20 ns20 n20 1.40625e-07
Cbase20 n20 0 2.5e-11
Rbleed20 n20 0 200000
Rser21 n20 ns21 0.034292856399
Lser21 ns21 n21 1.40625e-07
Cbase21 n21 0 2.5e-11
Rbleed21 n21 0 200000
Rser22 n21 ns22 0.034292856399
Lser22 ns22 n22 1.40625e-07
Cbase22 n22 0 2.5e-11
Rbleed22 n22 0 200000
Rser23 n22 ns23 0.034292856399
Lser23 ns23 n23 1.40625e-07
Cbase23 n23 0 2.5e-11
Rbleed23 n23 0 200000
Rser24 n23 ns24 0.034292856399
Lser24 ns24 n24 1.40625e-07
Cbase24 n24 0 2.5e-11
Rbleed24 n24 0 200000
Rser25 n24 ns25 0.034292856399
Lser25 ns25 n25 1.40625e-07
Cbase25 n25 0 2.5e-11
Rbleed25 n25 0 200000
Rser26 n25 ns26 0.034292856399
Lser26 ns26 n26 1.40625e-07
Cbase26 n26 0 2.5e-11
Rbleed26 n26 0 200000
Rser27 n26 ns27 0.034292856399
Lser27 ns27 n27 1.40625e-07
Cbase27 n27 0 2.5e-11
Rbleed27 n27 0 200000
Rser28 n27 ns28 0.034292856399
Lser28 ns28 n28 1.40625e-07
Cbase28 n28 0 2.5e-11
Rbleed28 n28 0 200000
Rser29 n28 ns29 0.034292856399
Lser29 ns29 n29 1.40625e-07
Cbase29 n29 0 2.5e-11
Rbleed29 n29 0 200000
Rser30 n29 ns30 0.034292856399
Lser30 ns30 n30 1.40625e-07
Cbase30 n30 0 2.5e-11
Rbleed30 n30 0 200000
Rser31 n30 ns31 0.034292856399
Lser31 ns31 n31 1.40625e-07
Cbase31 n31 0 2.5e-11
Rbleed31 n31 0 200000
Rser32 n31 ns32 0.034292856399
Lser32 ns32 n32 1.40625e-07
Cbase32 n32 0 2.5e-11
Rbleed32 n32 0 200000
Rser33 n32 ns33 0.034292856399
Lser33 ns33 n33 1.40625e-07
Cbase33 n33 0 2.5e-11
Rbleed33 n33 0 200000
Rser34 n33 ns34 0.034292856399
Lser34 ns34 n34 1.40625e-07
Cbase34 n34 0 2.5e-11
Rbleed34 n34 0 200000
Rser35 n34 ns35 0.034292856399
Lser35 ns35 n35 1.40625e-07
Cbase35 n35 0 2.5e-11
Rbleed35 n35 0 200000
Rser36 n35 ns36 0.034292856399
Lser36 ns36 n36 1.40625e-07
Cbase36 n36 0 2.5e-11
Rbleed36 n36 0 200000
Rser37 n36 ns37 0.034292856399
Lser37 ns37 n37 1.40625e-07
Cbase37 n37 0 2.5e-11
Rbleed37 n37 0 200000
Rser38 n37 ns38 0.034292856399
Lser38 ns38 n38 1.40625e-07
Cbase38 n38 0 2.5e-11
Rbleed38 n38 0 200000
Rser39 n38 ns39 0.034292856399
Lser39 ns39 n39 1.40625e-07
Cbase39 n39 0 2.5e-11
Rbleed39 n39 0 200000
Rser40 n39 ns40 0.034292856399
Lser40 ns40 n40 1.40625e-07
Cbase40 n40 0 2.5e-11
Rbleed40 n40 0 200000
Rser41 n40 ns41 0.034292856399
Lser41 ns41 n41 1.40625e-07
Cbase41 n41 0 2.5e-11
Rbleed41 n41 0 200000
Rser42 n41 ns42 0.034292856399
Lser42 ns42 n42 1.40625e-07
Cbase42 n42 0 2.5e-11
Rbleed42 n42 0 200000
Rser43 n42 ns43 0.034292856399
Lser43 ns43 n43 1.40625e-07
Cbase43 n43 0 2.5e-11
Rbleed43 n43 0 200000
Rser44 n43 ns44 0.034292856399
Lser44 ns44 n44 1.40625e-07
Cbase44 n44 0 2.5e-11
Rbleed44 n44 0 200000
Rser45 n44 ns45 0.034292856399
Lser45 ns45 n45 1.40625e-07
Cbase45 n45 0 2.5e-11
Rbleed45 n45 0 200000
Rser46 n45 ns46 0.034292856399
Lser46 ns46 n46 1.40625e-07
Cbase46 n46 0 2.5e-11
Rbleed46 n46 0 200000
Rser47 n46 ns47 0.034292856399
Lser47 ns47 n47 1.40625e-07
Cbase47 n47 0 2.5e-11
Rbleed47 n47 0 200000
Rser48 n47 ns48 0.034292856399
Lser48 ns48 n48 1.40625e-07
Cbase48 n48 0 2.5e-11
Rbleed48 n48 0 200000
Rser49 n48 ns49 0.034292856399
Lser49 ns49 n49 1.40625e-07
Cbase49 n49 0 2.5e-11
Rbleed49 n49 0 200000
Rser50 n49 ns50 0.034292856399
Lser50 ns50 n50 1.40625e-07
Cbase50 n50 0 2.5e-11
Rbleed50 n50 0 200000
Rser51 n50 ns51 0.034292856399
Lser51 ns51 n51 1.40625e-07
Cbase51 n51 0 2.5e-11
Rbleed51 n51 0 200000
Rser52 n51 ns52 0.034292856399
Lser52 ns52 n52 1.40625e-07
Cbase52 n52 0 2.5e-11
Rbleed52 n52 0 200000
Rser53 n52 ns53 0.034292856399
Lser53 ns53 n53 1.40625e-07
Cbase53 n53 0 2.5e-11
Rbleed53 n53 0 200000
Rser54 n53 ns54 0.034292856399
Lser54 ns54 n54 1.40625e-07
Cbase54 n54 0 2.5e-11
Rbleed54 n54 0 200000
Rser55 n54 ns55 0.034292856399
Lser55 ns55 n55 1.40625e-07
Cbase55 n55 0 2.5e-11
Rbleed55 n55 0 200000
Rser56 n55 ns56 0.034292856399
Lser56 ns56 n56 1.40625e-07
Cbase56 n56 0 2.5e-11
Rbleed56 n56 0 200000
Rser57 n56 ns57 0.034292856399
Lser57 ns57 n57 1.40625e-07
Cbase57 n57 0 2.5e-11
Rbleed57 n57 0 200000
Rser58 n57 ns58 0.034292856399
Lser58 ns58 n58 1.40625e-07
Cbase58 n58 0 2.5e-11
Rbleed58 n58 0 200000
Rser59 n58 ns59 0.034292856399
Lser59 ns59 n59 1.40625e-07
Cbase59 n59 0 2.5e-11
Rbleed59 n59 0 200000
Rser60 n59 ns60 0.034292856399
Lser60 ns60 n60 1.40625e-07
Cbase60 n60 0 2.5e-11
Rbleed60 n60 0 200000
Rser61 n60 ns61 0.034292856399
Lser61 ns61 n61 1.40625e-07
Cbase61 n61 0 2.5e-11
Rbleed61 n61 0 200000
Rser62 n61 ns62 0.034292856399
Lser62 ns62 n62 1.40625e-07
Cbase62 n62 0 2.5e-11
Rbleed62 n62 0 200000
Rser63 n62 ns63 0.034292856399
Lser63 ns63 n63 1.40625e-07
Cbase63 n63 0 2.5e-11
Rbleed63 n63 0 200000
Rser64 n63 ns64 0.034292856399
Lser64 ns64 n64 1.40625e-07
Cbase64 n64 0 2.5e-11
Rbleed64 n64 0 200000
Rser65 n64 ns65 0.034292856399
Lser65 ns65 n65 1.40625e-07
Cbase65 n65 0 2.5e-11
Rbleed65 n65 0 200000
Rser66 n65 ns66 0.034292856399
Lser66 ns66 n66 1.40625e-07
Cbase66 n66 0 2.5e-11
Rbleed66 n66 0 200000
Rser67 n66 ns67 0.034292856399
Lser67 ns67 n67 1.40625e-07
Cbase67 n67 0 2.5e-11
Rbleed67 n67 0 200000
Rser68 n67 ns68 0.034292856399
Lser68 ns68 n68 1.40625e-07
Cbase68 n68 0 2.5e-11
Rbleed68 n68 0 200000
Rser69 n68 ns69 0.034292856399
Lser69 ns69 n69 1.40625e-07
Cbase69 n69 0 2.5e-11
Rbleed69 n69 0 200000
Rser70 n69 ns70 0.034292856399
Lser70 ns70 n70 1.40625e-07
Cbase70 n70 0 2.5e-11
Rbleed70 n70 0 200000
Rser71 n70 ns71 0.034292856399
Lser71 ns71 n71 1.40625e-07
Cbase71 n71 0 2.5e-11
Rbleed71 n71 0 200000
Rser72 n71 ns72 0.034292856399
Lser72 ns72 n72 1.40625e-07
Cbase72 n72 0 2.5e-11
Rbleed72 n72 0 200000
Rser73 n72 ns73 0.034292856399
Lser73 ns73 n73 1.40625e-07
Cbase73 n73 0 2.5e-11
Rbleed73 n73 0 200000
Rser74 n73 ns74 0.034292856399
Lser74 ns74 n74 1.40625e-07
Cbase74 n74 0 2.5e-11
Rbleed74 n74 0 200000
Rser75 n74 ns75 0.034292856399
Lser75 ns75 n75 1.40625e-07
Cbase75 n75 0 2.5e-11
Rbleed75 n75 0 200000
Rser76 n75 ns76 0.034292856399
Lser76 ns76 n76 1.40625e-07
Cbase76 n76 0 2.5e-11
Rbleed76 n76 0 200000
Rser77 n76 ns77 0.034292856399
Lser77 ns77 n77 1.40625e-07
Cbase77 n77 0 2.5e-11
Rbleed77 n77 0 200000
Rser78 n77 ns78 0.034292856399
Lser78 ns78 n78 1.40625e-07
Cbase78 n78 0 2.5e-11
Rbleed78 n78 0 200000
Rser79 n78 ns79 0.034292856399
Lser79 ns79 n79 1.40625e-07
Cbase79 n79 0 2.5e-11
Rbleed79 n79 0 200000
Rser80 n79 ns80 0.034292856399
Lser80 ns80 n80 1.40625e-07
Cbase80 n80 0 2.5e-11
Rbleed80 n80 0 200000
Rext n80 ext_r 9.64285714286
Lext ext_r ext_l 2.3952998497e-07
Cext ext_l v150 4.7e-12
Rload150 v150 0 135
* Nonlinear magnetic core proxy: cubic shunt current plus small hysteretic loss.
.param kmag=0
.param gcore=1.4e-07
Bmag1 n1 0 I={(1)*kmag*V(n1)*V(n1)*V(n1) + gcore*V(n1)}
Bmag6 n6 0 I={(1)*kmag*V(n6)*V(n6)*V(n6) + gcore*V(n6)}
Bmag11 n11 0 I={(1)*kmag*V(n11)*V(n11)*V(n11) + gcore*V(n11)}
Bmag16 n16 0 I={(1)*kmag*V(n16)*V(n16)*V(n16) + gcore*V(n16)}
Bmag21 n21 0 I={(1)*kmag*V(n21)*V(n21)*V(n21) + gcore*V(n21)}
Bmag26 n26 0 I={(1)*kmag*V(n26)*V(n26)*V(n26) + gcore*V(n26)}
Bmag31 n31 0 I={(1)*kmag*V(n31)*V(n31)*V(n31) + gcore*V(n31)}
Bmag36 n36 0 I={(1)*kmag*V(n36)*V(n36)*V(n36) + gcore*V(n36)}
Bmag41 n41 0 I={(1)*kmag*V(n41)*V(n41)*V(n41) + gcore*V(n41)}
Bmag46 n46 0 I={(1)*kmag*V(n46)*V(n46)*V(n46) + gcore*V(n46)}
Bmag51 n51 0 I={(1)*kmag*V(n51)*V(n51)*V(n51) + gcore*V(n51)}
Bmag56 n56 0 I={(1)*kmag*V(n56)*V(n56)*V(n56) + gcore*V(n56)}
Bmag61 n61 0 I={(1)*kmag*V(n61)*V(n61)*V(n61) + gcore*V(n61)}
Bmag66 n66 0 I={(1)*kmag*V(n66)*V(n66)*V(n66) + gcore*V(n66)}
Bmag71 n71 0 I={(1)*kmag*V(n71)*V(n71)*V(n71) + gcore*V(n71)}
Bmag76 n76 0 I={(1)*kmag*V(n76)*V(n76)*V(n76) + gcore*V(n76)}
.control
set filetype=ascii
set wr_singlescale
set wr_vecnames
tran 5e-10 5.5e-07 0 2e-10
wrdata e005_nonlinear_magnetic_transmission_line_80c_75ohm_target_extraction_tran.csv time v(n0) v(n40) v(v150) i(Vsrc) i(Vbias)
.endc
.end

* e006_nonlinear_magnetic_transmission_line_128c_100ohm_extraction_plus_rejection
* electrical_family=nonlinear_magnetic_transmission_line
* behavioral helpers are scored; no direct 100 MHz or 150 MHz source appears in discovery rows.
* qpm_sign_flip=False; alternating_sections=True; varactor_stack=single
* role=discovery; cleanup=extraction_plus_rejection; source_only=True
.option method=gear maxord=2 reltol=2e-4 abstol=1e-12 vntol=1e-6 chgtol=1e-16 itl4=240
.model DVAR D(Is=1e-15 Rs=0.45 Cjo=1e-15 Vj=0.65 M=0.58 Bv=18 Ibv=1e-06)
Vbias vb 0 DC 3.4
Vsrc src 0 SIN(0 2.6 50000000)
Rsrc src n0 100
Rrawload n128 0 300
Cbase0 n0 0 1.171875e-11
Rbleed0 n0 0 200000
Rser1 n0 ns1 0.032173358544
Lser1 ns1 n1 1.171875e-07
Cbase1 n1 0 1.171875e-11
Rbleed1 n1 0 200000
Rser2 n1 ns2 0.032173358544
Lser2 ns2 n2 1.171875e-07
Cbase2 n2 0 1.171875e-11
Rbleed2 n2 0 200000
Rser3 n2 ns3 0.032173358544
Lser3 ns3 n3 1.171875e-07
Cbase3 n3 0 1.171875e-11
Rbleed3 n3 0 200000
Rser4 n3 ns4 0.032173358544
Lser4 ns4 n4 1.171875e-07
Cbase4 n4 0 1.171875e-11
Rbleed4 n4 0 200000
Rser5 n4 ns5 0.032173358544
Lser5 ns5 n5 1.171875e-07
Cbase5 n5 0 1.171875e-11
Rbleed5 n5 0 200000
Rser6 n5 ns6 0.032173358544
Lser6 ns6 n6 1.171875e-07
Cbase6 n6 0 1.171875e-11
Rbleed6 n6 0 200000
Rser7 n6 ns7 0.032173358544
Lser7 ns7 n7 1.171875e-07
Cbase7 n7 0 1.171875e-11
Rbleed7 n7 0 200000
Rser8 n7 ns8 0.032173358544
Lser8 ns8 n8 1.171875e-07
Cbase8 n8 0 1.171875e-11
Rbleed8 n8 0 200000
Rser9 n8 ns9 0.032173358544
Lser9 ns9 n9 1.171875e-07
Cbase9 n9 0 1.171875e-11
Rbleed9 n9 0 200000
Rser10 n9 ns10 0.032173358544
Lser10 ns10 n10 1.171875e-07
Cbase10 n10 0 1.171875e-11
Rbleed10 n10 0 200000
Rser11 n10 ns11 0.032173358544
Lser11 ns11 n11 1.171875e-07
Cbase11 n11 0 1.171875e-11
Rbleed11 n11 0 200000
Rser12 n11 ns12 0.032173358544
Lser12 ns12 n12 1.171875e-07
Cbase12 n12 0 1.171875e-11
Rbleed12 n12 0 200000
Rser13 n12 ns13 0.032173358544
Lser13 ns13 n13 1.171875e-07
Cbase13 n13 0 1.171875e-11
Rbleed13 n13 0 200000
Rser14 n13 ns14 0.032173358544
Lser14 ns14 n14 1.171875e-07
Cbase14 n14 0 1.171875e-11
Rbleed14 n14 0 200000
Rser15 n14 ns15 0.032173358544
Lser15 ns15 n15 1.171875e-07
Cbase15 n15 0 1.171875e-11
Rbleed15 n15 0 200000
Rser16 n15 ns16 0.032173358544
Lser16 ns16 n16 1.171875e-07
Cbase16 n16 0 1.171875e-11
Rbleed16 n16 0 200000
Rser17 n16 ns17 0.032173358544
Lser17 ns17 n17 1.171875e-07
Cbase17 n17 0 1.171875e-11
Rbleed17 n17 0 200000
Rser18 n17 ns18 0.032173358544
Lser18 ns18 n18 1.171875e-07
Cbase18 n18 0 1.171875e-11
Rbleed18 n18 0 200000
Rser19 n18 ns19 0.032173358544
Lser19 ns19 n19 1.171875e-07
Cbase19 n19 0 1.171875e-11
Rbleed19 n19 0 200000
Rser20 n19 ns20 0.032173358544
Lser20 ns20 n20 1.171875e-07
Cbase20 n20 0 1.171875e-11
Rbleed20 n20 0 200000
Rser21 n20 ns21 0.032173358544
Lser21 ns21 n21 1.171875e-07
Cbase21 n21 0 1.171875e-11
Rbleed21 n21 0 200000
Rser22 n21 ns22 0.032173358544
Lser22 ns22 n22 1.171875e-07
Cbase22 n22 0 1.171875e-11
Rbleed22 n22 0 200000
Rser23 n22 ns23 0.032173358544
Lser23 ns23 n23 1.171875e-07
Cbase23 n23 0 1.171875e-11
Rbleed23 n23 0 200000
Rser24 n23 ns24 0.032173358544
Lser24 ns24 n24 1.171875e-07
Cbase24 n24 0 1.171875e-11
Rbleed24 n24 0 200000
Rser25 n24 ns25 0.032173358544
Lser25 ns25 n25 1.171875e-07
Cbase25 n25 0 1.171875e-11
Rbleed25 n25 0 200000
Rser26 n25 ns26 0.032173358544
Lser26 ns26 n26 1.171875e-07
Cbase26 n26 0 1.171875e-11
Rbleed26 n26 0 200000
Rser27 n26 ns27 0.032173358544
Lser27 ns27 n27 1.171875e-07
Cbase27 n27 0 1.171875e-11
Rbleed27 n27 0 200000
Rser28 n27 ns28 0.032173358544
Lser28 ns28 n28 1.171875e-07
Cbase28 n28 0 1.171875e-11
Rbleed28 n28 0 200000
Rser29 n28 ns29 0.032173358544
Lser29 ns29 n29 1.171875e-07
Cbase29 n29 0 1.171875e-11
Rbleed29 n29 0 200000
Rser30 n29 ns30 0.032173358544
Lser30 ns30 n30 1.171875e-07
Cbase30 n30 0 1.171875e-11
Rbleed30 n30 0 200000
Rser31 n30 ns31 0.032173358544
Lser31 ns31 n31 1.171875e-07
Cbase31 n31 0 1.171875e-11
Rbleed31 n31 0 200000
Rser32 n31 ns32 0.032173358544
Lser32 ns32 n32 1.171875e-07
Cbase32 n32 0 1.171875e-11
Rbleed32 n32 0 200000
Rser33 n32 ns33 0.032173358544
Lser33 ns33 n33 1.171875e-07
Cbase33 n33 0 1.171875e-11
Rbleed33 n33 0 200000
Rser34 n33 ns34 0.032173358544
Lser34 ns34 n34 1.171875e-07
Cbase34 n34 0 1.171875e-11
Rbleed34 n34 0 200000
Rser35 n34 ns35 0.032173358544
Lser35 ns35 n35 1.171875e-07
Cbase35 n35 0 1.171875e-11
Rbleed35 n35 0 200000
Rser36 n35 ns36 0.032173358544
Lser36 ns36 n36 1.171875e-07
Cbase36 n36 0 1.171875e-11
Rbleed36 n36 0 200000
Rser37 n36 ns37 0.032173358544
Lser37 ns37 n37 1.171875e-07
Cbase37 n37 0 1.171875e-11
Rbleed37 n37 0 200000
Rser38 n37 ns38 0.032173358544
Lser38 ns38 n38 1.171875e-07
Cbase38 n38 0 1.171875e-11
Rbleed38 n38 0 200000
Rser39 n38 ns39 0.032173358544
Lser39 ns39 n39 1.171875e-07
Cbase39 n39 0 1.171875e-11
Rbleed39 n39 0 200000
Rser40 n39 ns40 0.032173358544
Lser40 ns40 n40 1.171875e-07
Cbase40 n40 0 1.171875e-11
Rbleed40 n40 0 200000
Rser41 n40 ns41 0.032173358544
Lser41 ns41 n41 1.171875e-07
Cbase41 n41 0 1.171875e-11
Rbleed41 n41 0 200000
Rser42 n41 ns42 0.032173358544
Lser42 ns42 n42 1.171875e-07
Cbase42 n42 0 1.171875e-11
Rbleed42 n42 0 200000
Rser43 n42 ns43 0.032173358544
Lser43 ns43 n43 1.171875e-07
Cbase43 n43 0 1.171875e-11
Rbleed43 n43 0 200000
Rser44 n43 ns44 0.032173358544
Lser44 ns44 n44 1.171875e-07
Cbase44 n44 0 1.171875e-11
Rbleed44 n44 0 200000
Rser45 n44 ns45 0.032173358544
Lser45 ns45 n45 1.171875e-07
Cbase45 n45 0 1.171875e-11
Rbleed45 n45 0 200000
Rser46 n45 ns46 0.032173358544
Lser46 ns46 n46 1.171875e-07
Cbase46 n46 0 1.171875e-11
Rbleed46 n46 0 200000
Rser47 n46 ns47 0.032173358544
Lser47 ns47 n47 1.171875e-07
Cbase47 n47 0 1.171875e-11
Rbleed47 n47 0 200000
Rser48 n47 ns48 0.032173358544
Lser48 ns48 n48 1.171875e-07
Cbase48 n48 0 1.171875e-11
Rbleed48 n48 0 200000
Rser49 n48 ns49 0.032173358544
Lser49 ns49 n49 1.171875e-07
Cbase49 n49 0 1.171875e-11
Rbleed49 n49 0 200000
Rser50 n49 ns50 0.032173358544
Lser50 ns50 n50 1.171875e-07
Cbase50 n50 0 1.171875e-11
Rbleed50 n50 0 200000
Rser51 n50 ns51 0.032173358544
Lser51 ns51 n51 1.171875e-07
Cbase51 n51 0 1.171875e-11
Rbleed51 n51 0 200000
Rser52 n51 ns52 0.032173358544
Lser52 ns52 n52 1.171875e-07
Cbase52 n52 0 1.171875e-11
Rbleed52 n52 0 200000
Rser53 n52 ns53 0.032173358544
Lser53 ns53 n53 1.171875e-07
Cbase53 n53 0 1.171875e-11
Rbleed53 n53 0 200000
Rser54 n53 ns54 0.032173358544
Lser54 ns54 n54 1.171875e-07
Cbase54 n54 0 1.171875e-11
Rbleed54 n54 0 200000
Rser55 n54 ns55 0.032173358544
Lser55 ns55 n55 1.171875e-07
Cbase55 n55 0 1.171875e-11
Rbleed55 n55 0 200000
Rser56 n55 ns56 0.032173358544
Lser56 ns56 n56 1.171875e-07
Cbase56 n56 0 1.171875e-11
Rbleed56 n56 0 200000
Rser57 n56 ns57 0.032173358544
Lser57 ns57 n57 1.171875e-07
Cbase57 n57 0 1.171875e-11
Rbleed57 n57 0 200000
Rser58 n57 ns58 0.032173358544
Lser58 ns58 n58 1.171875e-07
Cbase58 n58 0 1.171875e-11
Rbleed58 n58 0 200000
Rser59 n58 ns59 0.032173358544
Lser59 ns59 n59 1.171875e-07
Cbase59 n59 0 1.171875e-11
Rbleed59 n59 0 200000
Rser60 n59 ns60 0.032173358544
Lser60 ns60 n60 1.171875e-07
Cbase60 n60 0 1.171875e-11
Rbleed60 n60 0 200000
Rser61 n60 ns61 0.032173358544
Lser61 ns61 n61 1.171875e-07
Cbase61 n61 0 1.171875e-11
Rbleed61 n61 0 200000
Rser62 n61 ns62 0.032173358544
Lser62 ns62 n62 1.171875e-07
Cbase62 n62 0 1.171875e-11
Rbleed62 n62 0 200000
Rser63 n62 ns63 0.032173358544
Lser63 ns63 n63 1.171875e-07
Cbase63 n63 0 1.171875e-11
Rbleed63 n63 0 200000
Rser64 n63 ns64 0.032173358544
Lser64 ns64 n64 1.171875e-07
Cbase64 n64 0 1.171875e-11
Rbleed64 n64 0 200000
Rser65 n64 ns65 0.032173358544
Lser65 ns65 n65 1.171875e-07
Cbase65 n65 0 1.171875e-11
Rbleed65 n65 0 200000
Rser66 n65 ns66 0.032173358544
Lser66 ns66 n66 1.171875e-07
Cbase66 n66 0 1.171875e-11
Rbleed66 n66 0 200000
Rser67 n66 ns67 0.032173358544
Lser67 ns67 n67 1.171875e-07
Cbase67 n67 0 1.171875e-11
Rbleed67 n67 0 200000
Rser68 n67 ns68 0.032173358544
Lser68 ns68 n68 1.171875e-07
Cbase68 n68 0 1.171875e-11
Rbleed68 n68 0 200000
Rser69 n68 ns69 0.032173358544
Lser69 ns69 n69 1.171875e-07
Cbase69 n69 0 1.171875e-11
Rbleed69 n69 0 200000
Rser70 n69 ns70 0.032173358544
Lser70 ns70 n70 1.171875e-07
Cbase70 n70 0 1.171875e-11
Rbleed70 n70 0 200000
Rser71 n70 ns71 0.032173358544
Lser71 ns71 n71 1.171875e-07
Cbase71 n71 0 1.171875e-11
Rbleed71 n71 0 200000
Rser72 n71 ns72 0.032173358544
Lser72 ns72 n72 1.171875e-07
Cbase72 n72 0 1.171875e-11
Rbleed72 n72 0 200000
Rser73 n72 ns73 0.032173358544
Lser73 ns73 n73 1.171875e-07
Cbase73 n73 0 1.171875e-11
Rbleed73 n73 0 200000
Rser74 n73 ns74 0.032173358544
Lser74 ns74 n74 1.171875e-07
Cbase74 n74 0 1.171875e-11
Rbleed74 n74 0 200000
Rser75 n74 ns75 0.032173358544
Lser75 ns75 n75 1.171875e-07
Cbase75 n75 0 1.171875e-11
Rbleed75 n75 0 200000
Rser76 n75 ns76 0.032173358544
Lser76 ns76 n76 1.171875e-07
Cbase76 n76 0 1.171875e-11
Rbleed76 n76 0 200000
Rser77 n76 ns77 0.032173358544
Lser77 ns77 n77 1.171875e-07
Cbase77 n77 0 1.171875e-11
Rbleed77 n77 0 200000
Rser78 n77 ns78 0.032173358544
Lser78 ns78 n78 1.171875e-07
Cbase78 n78 0 1.171875e-11
Rbleed78 n78 0 200000
Rser79 n78 ns79 0.032173358544
Lser79 ns79 n79 1.171875e-07
Cbase79 n79 0 1.171875e-11
Rbleed79 n79 0 200000
Rser80 n79 ns80 0.032173358544
Lser80 ns80 n80 1.171875e-07
Cbase80 n80 0 1.171875e-11
Rbleed80 n80 0 200000
Rser81 n80 ns81 0.032173358544
Lser81 ns81 n81 1.171875e-07
Cbase81 n81 0 1.171875e-11
Rbleed81 n81 0 200000
Rser82 n81 ns82 0.032173358544
Lser82 ns82 n82 1.171875e-07
Cbase82 n82 0 1.171875e-11
Rbleed82 n82 0 200000
Rser83 n82 ns83 0.032173358544
Lser83 ns83 n83 1.171875e-07
Cbase83 n83 0 1.171875e-11
Rbleed83 n83 0 200000
Rser84 n83 ns84 0.032173358544
Lser84 ns84 n84 1.171875e-07
Cbase84 n84 0 1.171875e-11
Rbleed84 n84 0 200000
Rser85 n84 ns85 0.032173358544
Lser85 ns85 n85 1.171875e-07
Cbase85 n85 0 1.171875e-11
Rbleed85 n85 0 200000
Rser86 n85 ns86 0.032173358544
Lser86 ns86 n86 1.171875e-07
Cbase86 n86 0 1.171875e-11
Rbleed86 n86 0 200000
Rser87 n86 ns87 0.032173358544
Lser87 ns87 n87 1.171875e-07
Cbase87 n87 0 1.171875e-11
Rbleed87 n87 0 200000
Rser88 n87 ns88 0.032173358544
Lser88 ns88 n88 1.171875e-07
Cbase88 n88 0 1.171875e-11
Rbleed88 n88 0 200000
Rser89 n88 ns89 0.032173358544
Lser89 ns89 n89 1.171875e-07
Cbase89 n89 0 1.171875e-11
Rbleed89 n89 0 200000
Rser90 n89 ns90 0.032173358544
Lser90 ns90 n90 1.171875e-07
Cbase90 n90 0 1.171875e-11
Rbleed90 n90 0 200000
Rser91 n90 ns91 0.032173358544
Lser91 ns91 n91 1.171875e-07
Cbase91 n91 0 1.171875e-11
Rbleed91 n91 0 200000
Rser92 n91 ns92 0.032173358544
Lser92 ns92 n92 1.171875e-07
Cbase92 n92 0 1.171875e-11
Rbleed92 n92 0 200000
Rser93 n92 ns93 0.032173358544
Lser93 ns93 n93 1.171875e-07
Cbase93 n93 0 1.171875e-11
Rbleed93 n93 0 200000
Rser94 n93 ns94 0.032173358544
Lser94 ns94 n94 1.171875e-07
Cbase94 n94 0 1.171875e-11
Rbleed94 n94 0 200000
Rser95 n94 ns95 0.032173358544
Lser95 ns95 n95 1.171875e-07
Cbase95 n95 0 1.171875e-11
Rbleed95 n95 0 200000
Rser96 n95 ns96 0.032173358544
Lser96 ns96 n96 1.171875e-07
Cbase96 n96 0 1.171875e-11
Rbleed96 n96 0 200000
Rser97 n96 ns97 0.032173358544
Lser97 ns97 n97 1.171875e-07
Cbase97 n97 0 1.171875e-11
Rbleed97 n97 0 200000
Rser98 n97 ns98 0.032173358544
Lser98 ns98 n98 1.171875e-07
Cbase98 n98 0 1.171875e-11
Rbleed98 n98 0 200000
Rser99 n98 ns99 0.032173358544
Lser99 ns99 n99 1.171875e-07
Cbase99 n99 0 1.171875e-11
Rbleed99 n99 0 200000
Rser100 n99 ns100 0.032173358544
Lser100 ns100 n100 1.171875e-07
Cbase100 n100 0 1.171875e-11
Rbleed100 n100 0 200000
Rser101 n100 ns101 0.032173358544
Lser101 ns101 n101 1.171875e-07
Cbase101 n101 0 1.171875e-11
Rbleed101 n101 0 200000
Rser102 n101 ns102 0.032173358544
Lser102 ns102 n102 1.171875e-07
Cbase102 n102 0 1.171875e-11
Rbleed102 n102 0 200000
Rser103 n102 ns103 0.032173358544
Lser103 ns103 n103 1.171875e-07
Cbase103 n103 0 1.171875e-11
Rbleed103 n103 0 200000
Rser104 n103 ns104 0.032173358544
Lser104 ns104 n104 1.171875e-07
Cbase104 n104 0 1.171875e-11
Rbleed104 n104 0 200000
Rser105 n104 ns105 0.032173358544
Lser105 ns105 n105 1.171875e-07
Cbase105 n105 0 1.171875e-11
Rbleed105 n105 0 200000
Rser106 n105 ns106 0.032173358544
Lser106 ns106 n106 1.171875e-07
Cbase106 n106 0 1.171875e-11
Rbleed106 n106 0 200000
Rser107 n106 ns107 0.032173358544
Lser107 ns107 n107 1.171875e-07
Cbase107 n107 0 1.171875e-11
Rbleed107 n107 0 200000
Rser108 n107 ns108 0.032173358544
Lser108 ns108 n108 1.171875e-07
Cbase108 n108 0 1.171875e-11
Rbleed108 n108 0 200000
Rser109 n108 ns109 0.032173358544
Lser109 ns109 n109 1.171875e-07
Cbase109 n109 0 1.171875e-11
Rbleed109 n109 0 200000
Rser110 n109 ns110 0.032173358544
Lser110 ns110 n110 1.171875e-07
Cbase110 n110 0 1.171875e-11
Rbleed110 n110 0 200000
Rser111 n110 ns111 0.032173358544
Lser111 ns111 n111 1.171875e-07
Cbase111 n111 0 1.171875e-11
Rbleed111 n111 0 200000
Rser112 n111 ns112 0.032173358544
Lser112 ns112 n112 1.171875e-07
Cbase112 n112 0 1.171875e-11
Rbleed112 n112 0 200000
Rser113 n112 ns113 0.032173358544
Lser113 ns113 n113 1.171875e-07
Cbase113 n113 0 1.171875e-11
Rbleed113 n113 0 200000
Rser114 n113 ns114 0.032173358544
Lser114 ns114 n114 1.171875e-07
Cbase114 n114 0 1.171875e-11
Rbleed114 n114 0 200000
Rser115 n114 ns115 0.032173358544
Lser115 ns115 n115 1.171875e-07
Cbase115 n115 0 1.171875e-11
Rbleed115 n115 0 200000
Rser116 n115 ns116 0.032173358544
Lser116 ns116 n116 1.171875e-07
Cbase116 n116 0 1.171875e-11
Rbleed116 n116 0 200000
Rser117 n116 ns117 0.032173358544
Lser117 ns117 n117 1.171875e-07
Cbase117 n117 0 1.171875e-11
Rbleed117 n117 0 200000
Rser118 n117 ns118 0.032173358544
Lser118 ns118 n118 1.171875e-07
Cbase118 n118 0 1.171875e-11
Rbleed118 n118 0 200000
Rser119 n118 ns119 0.032173358544
Lser119 ns119 n119 1.171875e-07
Cbase119 n119 0 1.171875e-11
Rbleed119 n119 0 200000
Rser120 n119 ns120 0.032173358544
Lser120 ns120 n120 1.171875e-07
Cbase120 n120 0 1.171875e-11
Rbleed120 n120 0 200000
Rser121 n120 ns121 0.032173358544
Lser121 ns121 n121 1.171875e-07
Cbase121 n121 0 1.171875e-11
Rbleed121 n121 0 200000
Rser122 n121 ns122 0.032173358544
Lser122 ns122 n122 1.171875e-07
Cbase122 n122 0 1.171875e-11
Rbleed122 n122 0 200000
Rser123 n122 ns123 0.032173358544
Lser123 ns123 n123 1.171875e-07
Cbase123 n123 0 1.171875e-11
Rbleed123 n123 0 200000
Rser124 n123 ns124 0.032173358544
Lser124 ns124 n124 1.171875e-07
Cbase124 n124 0 1.171875e-11
Rbleed124 n124 0 200000
Rser125 n124 ns125 0.032173358544
Lser125 ns125 n125 1.171875e-07
Cbase125 n125 0 1.171875e-11
Rbleed125 n125 0 200000
Rser126 n125 ns126 0.032173358544
Lser126 ns126 n126 1.171875e-07
Cbase126 n126 0 1.171875e-11
Rbleed126 n126 0 200000
Rser127 n126 ns127 0.032173358544
Lser127 ns127 n127 1.171875e-07
Cbase127 n127 0 1.171875e-11
Rbleed127 n127 0 200000
Rser128 n127 ns128 0.032173358544
Lser128 ns128 n128 1.171875e-07
Cbase128 n128 0 1.171875e-11
Rbleed128 n128 0 200000
Rext n128 ext_r 10
Lext ext_r ext_l 2.3952998497e-07
Cext ext_l v150 4.7e-12
Rload150 v150 0 180
Rtrap50 n128 tr50_r 10
Ltrap50 tr50_r tr50_l 1.01321183642e-06
Ctrap50 tr50_l 0 1e-11
Rtrap100 n128 tr100_r 11.25
Ltrap100 tr100_r tr100_l 3.37737278808e-07
Ctrap100 tr100_l 0 7.5e-12
* Nonlinear magnetic core proxy: cubic shunt current plus small hysteretic loss.
.param kmag=0
.param gcore=1.8e-07
Bmag1 n1 0 I={(1)*kmag*V(n1)*V(n1)*V(n1) + gcore*V(n1)}
Bmag9 n9 0 I={(1)*kmag*V(n9)*V(n9)*V(n9) + gcore*V(n9)}
Bmag17 n17 0 I={(-1)*kmag*V(n17)*V(n17)*V(n17) + gcore*V(n17)}
Bmag25 n25 0 I={(-1)*kmag*V(n25)*V(n25)*V(n25) + gcore*V(n25)}
Bmag33 n33 0 I={(1)*kmag*V(n33)*V(n33)*V(n33) + gcore*V(n33)}
Bmag41 n41 0 I={(1)*kmag*V(n41)*V(n41)*V(n41) + gcore*V(n41)}
Bmag49 n49 0 I={(-1)*kmag*V(n49)*V(n49)*V(n49) + gcore*V(n49)}
Bmag57 n57 0 I={(-1)*kmag*V(n57)*V(n57)*V(n57) + gcore*V(n57)}
Bmag65 n65 0 I={(1)*kmag*V(n65)*V(n65)*V(n65) + gcore*V(n65)}
Bmag73 n73 0 I={(1)*kmag*V(n73)*V(n73)*V(n73) + gcore*V(n73)}
Bmag81 n81 0 I={(-1)*kmag*V(n81)*V(n81)*V(n81) + gcore*V(n81)}
Bmag89 n89 0 I={(-1)*kmag*V(n89)*V(n89)*V(n89) + gcore*V(n89)}
Bmag97 n97 0 I={(1)*kmag*V(n97)*V(n97)*V(n97) + gcore*V(n97)}
Bmag105 n105 0 I={(1)*kmag*V(n105)*V(n105)*V(n105) + gcore*V(n105)}
Bmag113 n113 0 I={(-1)*kmag*V(n113)*V(n113)*V(n113) + gcore*V(n113)}
Bmag121 n121 0 I={(-1)*kmag*V(n121)*V(n121)*V(n121) + gcore*V(n121)}
.control
set filetype=ascii
set wr_singlescale
set wr_vecnames
tran 5e-10 5.5e-07 0 2e-10
wrdata e006_nonlinear_magnetic_transmission_line_128c_100ohm_extraction_plus_rejection_tran.csv time v(n0) v(n64) v(v150) i(Vsrc) i(Vbias)
.endc
.end

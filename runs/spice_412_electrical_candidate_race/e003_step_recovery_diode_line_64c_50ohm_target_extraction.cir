* e003_step_recovery_diode_line_64c_50ohm_target_extraction
* electrical_family=step_recovery_diode_line
* behavioral helpers are scored; no direct 100 MHz or 150 MHz source appears in discovery rows.
* qpm_sign_flip=False; alternating_sections=False; varactor_stack=single
* role=discovery; cleanup=target_extraction; source_only=True
.option method=gear maxord=2 reltol=2e-4 abstol=1e-12 vntol=1e-6 chgtol=1e-16 itl4=240
.model DVAR D(Is=1e-15 Rs=0.45 Cjo=1e-15 Vj=0.65 M=0.58 Bv=18 Ibv=1e-06)
Vbias vb 0 DC 3.4
Vsrc src 0 SIN(0 2.5 50000000)
Rsrc src n0 50
Rrawload n64 0 150
Cbase0 n0 0 2.375e-11
Rbleed0 n0 0 200000
Rser1 n0 ns1 0.0175
Lser1 ns1 n1 5.9375e-08
Cbase1 n1 0 2.375e-11
Rbleed1 n1 0 200000
Rser2 n1 ns2 0.0175
Lser2 ns2 n2 5.9375e-08
Cbase2 n2 0 2.375e-11
Rbleed2 n2 0 200000
Rser3 n2 ns3 0.0175
Lser3 ns3 n3 5.9375e-08
Cbase3 n3 0 2.375e-11
Rbleed3 n3 0 200000
Rser4 n3 ns4 0.0175
Lser4 ns4 n4 5.9375e-08
Cbase4 n4 0 2.375e-11
Rbleed4 n4 0 200000
Rser5 n4 ns5 0.0175
Lser5 ns5 n5 5.9375e-08
Cbase5 n5 0 2.375e-11
Rbleed5 n5 0 200000
Rser6 n5 ns6 0.0175
Lser6 ns6 n6 5.9375e-08
Cbase6 n6 0 2.375e-11
Rbleed6 n6 0 200000
Rser7 n6 ns7 0.0175
Lser7 ns7 n7 5.9375e-08
Cbase7 n7 0 2.375e-11
Rbleed7 n7 0 200000
Rser8 n7 ns8 0.0175
Lser8 ns8 n8 5.9375e-08
Cbase8 n8 0 2.375e-11
Rbleed8 n8 0 200000
Rser9 n8 ns9 0.0175
Lser9 ns9 n9 5.9375e-08
Cbase9 n9 0 2.375e-11
Rbleed9 n9 0 200000
Rser10 n9 ns10 0.0175
Lser10 ns10 n10 5.9375e-08
Cbase10 n10 0 2.375e-11
Rbleed10 n10 0 200000
Rser11 n10 ns11 0.0175
Lser11 ns11 n11 5.9375e-08
Cbase11 n11 0 2.375e-11
Rbleed11 n11 0 200000
Rser12 n11 ns12 0.0175
Lser12 ns12 n12 5.9375e-08
Cbase12 n12 0 2.375e-11
Rbleed12 n12 0 200000
Rser13 n12 ns13 0.0175
Lser13 ns13 n13 5.9375e-08
Cbase13 n13 0 2.375e-11
Rbleed13 n13 0 200000
Rser14 n13 ns14 0.0175
Lser14 ns14 n14 5.9375e-08
Cbase14 n14 0 2.375e-11
Rbleed14 n14 0 200000
Rser15 n14 ns15 0.0175
Lser15 ns15 n15 5.9375e-08
Cbase15 n15 0 2.375e-11
Rbleed15 n15 0 200000
Rser16 n15 ns16 0.0175
Lser16 ns16 n16 5.9375e-08
Cbase16 n16 0 2.375e-11
Rbleed16 n16 0 200000
Rser17 n16 ns17 0.0175
Lser17 ns17 n17 5.9375e-08
Cbase17 n17 0 2.375e-11
Rbleed17 n17 0 200000
Rser18 n17 ns18 0.0175
Lser18 ns18 n18 5.9375e-08
Cbase18 n18 0 2.375e-11
Rbleed18 n18 0 200000
Rser19 n18 ns19 0.0175
Lser19 ns19 n19 5.9375e-08
Cbase19 n19 0 2.375e-11
Rbleed19 n19 0 200000
Rser20 n19 ns20 0.0175
Lser20 ns20 n20 5.9375e-08
Cbase20 n20 0 2.375e-11
Rbleed20 n20 0 200000
Rser21 n20 ns21 0.0175
Lser21 ns21 n21 5.9375e-08
Cbase21 n21 0 2.375e-11
Rbleed21 n21 0 200000
Rser22 n21 ns22 0.0175
Lser22 ns22 n22 5.9375e-08
Cbase22 n22 0 2.375e-11
Rbleed22 n22 0 200000
Rser23 n22 ns23 0.0175
Lser23 ns23 n23 5.9375e-08
Cbase23 n23 0 2.375e-11
Rbleed23 n23 0 200000
Rser24 n23 ns24 0.0175
Lser24 ns24 n24 5.9375e-08
Cbase24 n24 0 2.375e-11
Rbleed24 n24 0 200000
Rser25 n24 ns25 0.0175
Lser25 ns25 n25 5.9375e-08
Cbase25 n25 0 2.375e-11
Rbleed25 n25 0 200000
Rser26 n25 ns26 0.0175
Lser26 ns26 n26 5.9375e-08
Cbase26 n26 0 2.375e-11
Rbleed26 n26 0 200000
Rser27 n26 ns27 0.0175
Lser27 ns27 n27 5.9375e-08
Cbase27 n27 0 2.375e-11
Rbleed27 n27 0 200000
Rser28 n27 ns28 0.0175
Lser28 ns28 n28 5.9375e-08
Cbase28 n28 0 2.375e-11
Rbleed28 n28 0 200000
Rser29 n28 ns29 0.0175
Lser29 ns29 n29 5.9375e-08
Cbase29 n29 0 2.375e-11
Rbleed29 n29 0 200000
Rser30 n29 ns30 0.0175
Lser30 ns30 n30 5.9375e-08
Cbase30 n30 0 2.375e-11
Rbleed30 n30 0 200000
Rser31 n30 ns31 0.0175
Lser31 ns31 n31 5.9375e-08
Cbase31 n31 0 2.375e-11
Rbleed31 n31 0 200000
Rser32 n31 ns32 0.0175
Lser32 ns32 n32 5.9375e-08
Cbase32 n32 0 2.375e-11
Rbleed32 n32 0 200000
Rser33 n32 ns33 0.0175
Lser33 ns33 n33 5.9375e-08
Cbase33 n33 0 2.375e-11
Rbleed33 n33 0 200000
Rser34 n33 ns34 0.0175
Lser34 ns34 n34 5.9375e-08
Cbase34 n34 0 2.375e-11
Rbleed34 n34 0 200000
Rser35 n34 ns35 0.0175
Lser35 ns35 n35 5.9375e-08
Cbase35 n35 0 2.375e-11
Rbleed35 n35 0 200000
Rser36 n35 ns36 0.0175
Lser36 ns36 n36 5.9375e-08
Cbase36 n36 0 2.375e-11
Rbleed36 n36 0 200000
Rser37 n36 ns37 0.0175
Lser37 ns37 n37 5.9375e-08
Cbase37 n37 0 2.375e-11
Rbleed37 n37 0 200000
Rser38 n37 ns38 0.0175
Lser38 ns38 n38 5.9375e-08
Cbase38 n38 0 2.375e-11
Rbleed38 n38 0 200000
Rser39 n38 ns39 0.0175
Lser39 ns39 n39 5.9375e-08
Cbase39 n39 0 2.375e-11
Rbleed39 n39 0 200000
Rser40 n39 ns40 0.0175
Lser40 ns40 n40 5.9375e-08
Cbase40 n40 0 2.375e-11
Rbleed40 n40 0 200000
Rser41 n40 ns41 0.0175
Lser41 ns41 n41 5.9375e-08
Cbase41 n41 0 2.375e-11
Rbleed41 n41 0 200000
Rser42 n41 ns42 0.0175
Lser42 ns42 n42 5.9375e-08
Cbase42 n42 0 2.375e-11
Rbleed42 n42 0 200000
Rser43 n42 ns43 0.0175
Lser43 ns43 n43 5.9375e-08
Cbase43 n43 0 2.375e-11
Rbleed43 n43 0 200000
Rser44 n43 ns44 0.0175
Lser44 ns44 n44 5.9375e-08
Cbase44 n44 0 2.375e-11
Rbleed44 n44 0 200000
Rser45 n44 ns45 0.0175
Lser45 ns45 n45 5.9375e-08
Cbase45 n45 0 2.375e-11
Rbleed45 n45 0 200000
Rser46 n45 ns46 0.0175
Lser46 ns46 n46 5.9375e-08
Cbase46 n46 0 2.375e-11
Rbleed46 n46 0 200000
Rser47 n46 ns47 0.0175
Lser47 ns47 n47 5.9375e-08
Cbase47 n47 0 2.375e-11
Rbleed47 n47 0 200000
Rser48 n47 ns48 0.0175
Lser48 ns48 n48 5.9375e-08
Cbase48 n48 0 2.375e-11
Rbleed48 n48 0 200000
Rser49 n48 ns49 0.0175
Lser49 ns49 n49 5.9375e-08
Cbase49 n49 0 2.375e-11
Rbleed49 n49 0 200000
Rser50 n49 ns50 0.0175
Lser50 ns50 n50 5.9375e-08
Cbase50 n50 0 2.375e-11
Rbleed50 n50 0 200000
Rser51 n50 ns51 0.0175
Lser51 ns51 n51 5.9375e-08
Cbase51 n51 0 2.375e-11
Rbleed51 n51 0 200000
Rser52 n51 ns52 0.0175
Lser52 ns52 n52 5.9375e-08
Cbase52 n52 0 2.375e-11
Rbleed52 n52 0 200000
Rser53 n52 ns53 0.0175
Lser53 ns53 n53 5.9375e-08
Cbase53 n53 0 2.375e-11
Rbleed53 n53 0 200000
Rser54 n53 ns54 0.0175
Lser54 ns54 n54 5.9375e-08
Cbase54 n54 0 2.375e-11
Rbleed54 n54 0 200000
Rser55 n54 ns55 0.0175
Lser55 ns55 n55 5.9375e-08
Cbase55 n55 0 2.375e-11
Rbleed55 n55 0 200000
Rser56 n55 ns56 0.0175
Lser56 ns56 n56 5.9375e-08
Cbase56 n56 0 2.375e-11
Rbleed56 n56 0 200000
Rser57 n56 ns57 0.0175
Lser57 ns57 n57 5.9375e-08
Cbase57 n57 0 2.375e-11
Rbleed57 n57 0 200000
Rser58 n57 ns58 0.0175
Lser58 ns58 n58 5.9375e-08
Cbase58 n58 0 2.375e-11
Rbleed58 n58 0 200000
Rser59 n58 ns59 0.0175
Lser59 ns59 n59 5.9375e-08
Cbase59 n59 0 2.375e-11
Rbleed59 n59 0 200000
Rser60 n59 ns60 0.0175
Lser60 ns60 n60 5.9375e-08
Cbase60 n60 0 2.375e-11
Rbleed60 n60 0 200000
Rser61 n60 ns61 0.0175
Lser61 ns61 n61 5.9375e-08
Cbase61 n61 0 2.375e-11
Rbleed61 n61 0 200000
Rser62 n61 ns62 0.0175
Lser62 ns62 n62 5.9375e-08
Cbase62 n62 0 2.375e-11
Rbleed62 n62 0 200000
Rser63 n62 ns63 0.0175
Lser63 ns63 n63 5.9375e-08
Cbase63 n63 0 2.375e-11
Rbleed63 n63 0 200000
Rser64 n63 ns64 0.0175
Lser64 ns64 n64 5.9375e-08
Cbase64 n64 0 2.375e-11
Rbleed64 n64 0 200000
Rext n64 ext_r 7.5
Lext ext_r ext_l 2.3952998497e-07
Cext ext_l v150 4.7e-12
Rload150 v150 0 90
* Step-recovery charge-storage proxy: nonlinear current from local line voltage.
.param kstep2=3.78e-06
.param kstep3=1.26e-06
Bstep1 n1 0 I={(1)*(kstep2*V(n1)*V(n1) + kstep3*V(n1)*V(n1)*V(n1))}
Bstep5 n5 0 I={(1)*(kstep2*V(n5)*V(n5) + kstep3*V(n5)*V(n5)*V(n5))}
Bstep9 n9 0 I={(1)*(kstep2*V(n9)*V(n9) + kstep3*V(n9)*V(n9)*V(n9))}
Bstep13 n13 0 I={(1)*(kstep2*V(n13)*V(n13) + kstep3*V(n13)*V(n13)*V(n13))}
Bstep17 n17 0 I={(1)*(kstep2*V(n17)*V(n17) + kstep3*V(n17)*V(n17)*V(n17))}
Bstep21 n21 0 I={(1)*(kstep2*V(n21)*V(n21) + kstep3*V(n21)*V(n21)*V(n21))}
Bstep25 n25 0 I={(1)*(kstep2*V(n25)*V(n25) + kstep3*V(n25)*V(n25)*V(n25))}
Bstep29 n29 0 I={(1)*(kstep2*V(n29)*V(n29) + kstep3*V(n29)*V(n29)*V(n29))}
Bstep33 n33 0 I={(1)*(kstep2*V(n33)*V(n33) + kstep3*V(n33)*V(n33)*V(n33))}
Bstep37 n37 0 I={(1)*(kstep2*V(n37)*V(n37) + kstep3*V(n37)*V(n37)*V(n37))}
Bstep41 n41 0 I={(1)*(kstep2*V(n41)*V(n41) + kstep3*V(n41)*V(n41)*V(n41))}
Bstep45 n45 0 I={(1)*(kstep2*V(n45)*V(n45) + kstep3*V(n45)*V(n45)*V(n45))}
Bstep49 n49 0 I={(1)*(kstep2*V(n49)*V(n49) + kstep3*V(n49)*V(n49)*V(n49))}
Bstep53 n53 0 I={(1)*(kstep2*V(n53)*V(n53) + kstep3*V(n53)*V(n53)*V(n53))}
Bstep57 n57 0 I={(1)*(kstep2*V(n57)*V(n57) + kstep3*V(n57)*V(n57)*V(n57))}
Bstep61 n61 0 I={(1)*(kstep2*V(n61)*V(n61) + kstep3*V(n61)*V(n61)*V(n61))}
.control
set filetype=ascii
set wr_singlescale
set wr_vecnames
tran 5e-10 5.5e-07 0 2e-10
wrdata e003_step_recovery_diode_line_64c_50ohm_target_extraction_tran.csv time v(n0) v(n32) v(v150) i(Vsrc) i(Vbias)
.endc
.end
